* Entry 109: isolated memory; ideal test inputs, NOT a hardware DFE
.lib "C:/Users/DELL/Desktop/serdes-dsp-framework-main/nebula/device/spice/pdk_trim/sections/sky130_ctle_pfet__tt.lib.spice" tt
.temp 27
Vdd vdd 0 1.8
Vset bx 0 PWL(
+ 0 1.8
+ 5e-10 1.8
+ 5.02e-10 0
+ 5.98e-10 0
+ 6e-10 1.8
+ 9e-10 1.8
+ 9.02e-10 0
+ 9.980000000000001e-10 0
+ 1e-09 1.8
+ 1.5e-09 1.8
+ 1.502e-09 0
+ 1.598e-09 0
+ 1.6e-09 1.8
+ 1.7e-09 1.8
+ 1.702e-09 0
+ 1.798e-09 0
+ 1.8e-09 1.8
+ 2.1e-09 1.8
+ 2.102e-09 0
+ 2.198e-09 0
+ 2.2e-09 1.8
+ 2.5e-09 1.8
+ 2.502e-09 0
+ 2.598e-09 0
+ 2.6e-09 1.8
+ 2.9e-09 1.8
+ 2.902e-09 0
+ 2.998e-09 0
+ 3e-09 1.8
+ 3.1e-09 1.8
+ 3.102e-09 0
+ 3.198e-09 0
+ 3.2e-09 1.8
+ 3.3e-09 1.8
+ 3.302e-09 0
+ 3.398e-09 0
+ 3.4e-09 1.8
+ 3.9e-09 1.8
+ 3.902e-09 0
+ 3.998e-09 0
+ 4e-09 1.8
+ 4.1e-09 1.8
+ 4.102e-09 0
+ 4.198000000000001e-09 0
+ 4.2e-09 1.8
+ 4.7e-09 1.8
+ 4.702e-09 0
+ 4.798e-09 0
+ 4.8e-09 1.8
+ 5.3e-09 1.8
+ 5.302e-09 0
+ 5.398000000000001e-09 0
+ 5.4e-09 1.8
+ 5.9e-09 1.8
+ 5.902e-09 0
+ 5.998e-09 0
+ 6e-09 1.8
+ 6.1e-09 1.8
+ 6.102e-09 0
+ 6.198e-09 0
+ 6.2e-09 1.8
+ 6.7e-09 1.8
+ 6.702e-09 0
+ 6.798000000000001e-09 0
+ 6.800000000000001e-09 1.8
+ 6.900000000000001e-09 1.8
+ 6.902e-09 0
+ 6.998000000000001e-09 0
+ 7.000000000000001e-09 1.8
+ 7.1e-09 1.8
+ 7.102e-09 0
+ 7.198e-09 0
+ 7.2e-09 1.8
+ 7.3e-09 1.8
+ 7.302e-09 0
+ 7.398e-09 0
+ 7.4e-09 1.8
+ 7.6e-09 1.8
+ )
Vreset by 0 PWL(
+ 0 1.8
+ 3e-10 1.8
+ 3.02e-10 0
+ 3.98e-10 0
+ 4e-10 1.8
+ 7.000000000000001e-10 1.8
+ 7.020000000000001e-10 0
+ 7.98e-10 0
+ 8e-10 1.8
+ 1.1e-09 1.8
+ 1.102e-09 0
+ 1.198e-09 0
+ 1.2e-09 1.8
+ 1.3e-09 1.8
+ 1.302e-09 0
+ 1.398e-09 0
+ 1.4e-09 1.8
+ 1.9e-09 1.8
+ 1.902e-09 0
+ 1.998e-09 0
+ 2e-09 1.8
+ 2.3e-09 1.8
+ 2.302e-09 0
+ 2.398e-09 0
+ 2.4e-09 1.8
+ 2.7e-09 1.8
+ 2.702e-09 0
+ 2.798e-09 0
+ 2.8e-09 1.8
+ 3.5e-09 1.8
+ 3.502000000000001e-09 0
+ 3.598e-09 0
+ 3.6e-09 1.8
+ 3.7e-09 1.8
+ 3.702e-09 0
+ 3.798e-09 0
+ 3.8e-09 1.8
+ 4.3e-09 1.8
+ 4.302e-09 0
+ 4.398000000000001e-09 0
+ 4.400000000000001e-09 1.8
+ 4.5e-09 1.8
+ 4.502e-09 0
+ 4.598e-09 0
+ 4.6e-09 1.8
+ 4.9e-09 1.8
+ 4.902e-09 0
+ 4.998e-09 0
+ 5e-09 1.8
+ 5.1e-09 1.8
+ 5.102e-09 0
+ 5.198e-09 0
+ 5.2e-09 1.8
+ 5.5e-09 1.8
+ 5.502e-09 0
+ 5.598000000000001e-09 0
+ 5.600000000000001e-09 1.8
+ 5.700000000000001e-09 1.8
+ 5.702e-09 0
+ 5.798000000000001e-09 0
+ 5.800000000000001e-09 1.8
+ 6.3e-09 1.8
+ 6.302e-09 0
+ 6.398e-09 0
+ 6.4e-09 1.8
+ 6.5e-09 1.8
+ 6.502e-09 0
+ 6.598000000000001e-09 0
+ 6.6e-09 1.8
+ 7.6e-09 1.8
+ )
Xq_p1 q bx vdd vdd sky130_fd_pr__pfet_01v8 w=4 l=0.15 nf=2
Xq_p2 q qb vdd vdd sky130_fd_pr__pfet_01v8 w=4 l=0.15 nf=2
Xq_n1 q bx q_series 0 sky130_fd_pr__nfet_01v8 w=4 l=0.15 nf=2
Xq_n2 q_series qb 0 0 sky130_fd_pr__nfet_01v8 w=4 l=0.15 nf=2
Xqb_p1 qb by vdd vdd sky130_fd_pr__pfet_01v8 w=4 l=0.15 nf=2
Xqb_p2 qb q vdd vdd sky130_fd_pr__pfet_01v8 w=4 l=0.15 nf=2
Xqb_n1 qb by qb_series 0 sky130_fd_pr__nfet_01v8 w=4 l=0.15 nf=2
Xqb_n2 qb_series q 0 0 sky130_fd_pr__nfet_01v8 w=4 l=0.15 nf=2
.control
set noaskquit
set numdgt=15
tran 1p 7.6e-09 0 1p
wrdata trace.txt v(bx) v(by) v(q) v(qb) i(vdd) i(vset) i(vreset)
quit
.endc
.end
