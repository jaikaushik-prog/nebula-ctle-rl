* Entry 106: decision and hold only; external clock/input, no DFE feedback
.lib "C:/Users/DELL/Desktop/serdes-dsp-framework-main/nebula/device/spice/pdk_trim/sections/sky130_ctle_pfet__tt.lib.spice" tt
.temp 27
Vdd vdd 0 1.8
Vclk clk 0 PULSE(0 1.8 300p 2p 2p 96p 200p)
Vinp inp 0 PWL(
+ 0 1.339486680057613
+ 4e-10 1.339486680057613
+ 4.02e-10 1.389486680057613
+ 6e-10 1.389486680057613
+ 6.02e-10 1.339486680057613
+ 8e-10 1.339486680057613
+ 8.02e-10 1.389486680057613
+ 1e-09 1.389486680057613
+ 1.002e-09 1.339486680057613
+ 1.2e-09 1.339486680057613
+ 1.202e-09 1.339486680057613
+ 1.4e-09 1.339486680057613
+ 1.402e-09 1.389486680057613
+ 1.6e-09 1.389486680057613
+ 1.602e-09 1.389486680057613
+ 1.8e-09 1.389486680057613
+ 1.802e-09 1.339486680057613
+ 2e-09 1.339486680057613
+ 2.002e-09 1.389486680057613
+ 2.2e-09 1.389486680057613
+ 2.202e-09 1.339486680057613
+ 2.4e-09 1.339486680057613
+ 2.402e-09 1.389486680057613
+ 2.6e-09 1.389486680057613
+ 2.602e-09 1.339486680057613
+ 2.8e-09 1.339486680057613
+ 2.802e-09 1.389486680057613
+ 3e-09 1.389486680057613
+ 3.002e-09 1.389486680057613
+ 3.2e-09 1.389486680057613
+ 3.202e-09 1.389486680057613
+ 3.4e-09 1.389486680057613
+ 3.402e-09 1.339486680057613
+ 3.6e-09 1.339486680057613
+ 3.602e-09 1.339486680057613
+ 3.8e-09 1.339486680057613
+ 3.802e-09 1.389486680057613
+ 4e-09 1.389486680057613
+ 4.002e-09 1.389486680057613
+ 4.2e-09 1.389486680057613
+ 4.202e-09 1.339486680057613
+ 4.400000000000001e-09 1.339486680057613
+ 4.402e-09 1.339486680057613
+ 4.6e-09 1.339486680057613
+ 4.602e-09 1.389486680057613
+ 4.8e-09 1.389486680057613
+ 4.802e-09 1.339486680057613
+ 5e-09 1.339486680057613
+ 5.002e-09 1.339486680057613
+ 5.2e-09 1.339486680057613
+ 5.202e-09 1.389486680057613
+ 5.4e-09 1.389486680057613
+ 5.402e-09 1.339486680057613
+ 5.600000000000001e-09 1.339486680057613
+ 5.602e-09 1.339486680057613
+ 5.8e-09 1.339486680057613
+ 5.802e-09 1.389486680057613
+ 6e-09 1.389486680057613
+ 6.002e-09 1.389486680057613
+ 6.2e-09 1.389486680057613
+ 6.202e-09 1.339486680057613
+ 6.4e-09 1.339486680057613
+ 6.402e-09 1.339486680057613
+ 6.6e-09 1.339486680057613
+ 6.602e-09 1.389486680057613
+ 6.800000000000001e-09 1.389486680057613
+ 6.802e-09 1.389486680057613
+ 7.000000000000001e-09 1.389486680057613
+ 7.002e-09 1.389486680057613
+ 7.2e-09 1.389486680057613
+ 7.202e-09 1.389486680057613
+ 7.6e-09 1.389486680057613
+ )
Vinn inn 0 PWL(
+ 0 1.389486680057613
+ 4e-10 1.389486680057613
+ 4.02e-10 1.339486680057613
+ 6e-10 1.339486680057613
+ 6.02e-10 1.389486680057613
+ 8e-10 1.389486680057613
+ 8.02e-10 1.339486680057613
+ 1e-09 1.339486680057613
+ 1.002e-09 1.389486680057613
+ 1.2e-09 1.389486680057613
+ 1.202e-09 1.389486680057613
+ 1.4e-09 1.389486680057613
+ 1.402e-09 1.339486680057613
+ 1.6e-09 1.339486680057613
+ 1.602e-09 1.339486680057613
+ 1.8e-09 1.339486680057613
+ 1.802e-09 1.389486680057613
+ 2e-09 1.389486680057613
+ 2.002e-09 1.339486680057613
+ 2.2e-09 1.339486680057613
+ 2.202e-09 1.389486680057613
+ 2.4e-09 1.389486680057613
+ 2.402e-09 1.339486680057613
+ 2.6e-09 1.339486680057613
+ 2.602e-09 1.389486680057613
+ 2.8e-09 1.389486680057613
+ 2.802e-09 1.339486680057613
+ 3e-09 1.339486680057613
+ 3.002e-09 1.339486680057613
+ 3.2e-09 1.339486680057613
+ 3.202e-09 1.339486680057613
+ 3.4e-09 1.339486680057613
+ 3.402e-09 1.389486680057613
+ 3.6e-09 1.389486680057613
+ 3.602e-09 1.389486680057613
+ 3.8e-09 1.389486680057613
+ 3.802e-09 1.339486680057613
+ 4e-09 1.339486680057613
+ 4.002e-09 1.339486680057613
+ 4.2e-09 1.339486680057613
+ 4.202e-09 1.389486680057613
+ 4.400000000000001e-09 1.389486680057613
+ 4.402e-09 1.389486680057613
+ 4.6e-09 1.389486680057613
+ 4.602e-09 1.339486680057613
+ 4.8e-09 1.339486680057613
+ 4.802e-09 1.389486680057613
+ 5e-09 1.389486680057613
+ 5.002e-09 1.389486680057613
+ 5.2e-09 1.389486680057613
+ 5.202e-09 1.339486680057613
+ 5.4e-09 1.339486680057613
+ 5.402e-09 1.389486680057613
+ 5.600000000000001e-09 1.389486680057613
+ 5.602e-09 1.389486680057613
+ 5.8e-09 1.389486680057613
+ 5.802e-09 1.339486680057613
+ 6e-09 1.339486680057613
+ 6.002e-09 1.339486680057613
+ 6.2e-09 1.339486680057613
+ 6.202e-09 1.389486680057613
+ 6.4e-09 1.389486680057613
+ 6.402e-09 1.389486680057613
+ 6.6e-09 1.389486680057613
+ 6.602e-09 1.339486680057613
+ 6.800000000000001e-09 1.339486680057613
+ 6.802e-09 1.339486680057613
+ 7.000000000000001e-09 1.339486680057613
+ 7.002e-09 1.339486680057613
+ 7.2e-09 1.339486680057613
+ 7.202e-09 1.339486680057613
+ 7.6e-09 1.339486680057613
+ )
Xin1 p inp tail 0 sky130_fd_pr__nfet_01v8 w=8 l=0.15 nf=4
Xin2 n inn tail 0 sky130_fd_pr__nfet_01v8 w=8 l=0.15 nf=4
Xregen1 x y p 0 sky130_fd_pr__nfet_01v8 w=8 l=0.15 nf=4
Xregen2 y x n 0 sky130_fd_pr__nfet_01v8 w=8 l=0.15 nf=4
Xpull1 x y vdd vdd sky130_fd_pr__pfet_01v8 w=8 l=0.15 nf=4
Xpull2 y x vdd vdd sky130_fd_pr__pfet_01v8 w=8 l=0.15 nf=4
Xtail tail clk 0 0 sky130_fd_pr__nfet_01v8 w=16 l=0.15 nf=8
Xpre_p p clk vdd vdd sky130_fd_pr__pfet_01v8 w=8 l=0.15 nf=4
Xpre_n n clk vdd vdd sky130_fd_pr__pfet_01v8 w=8 l=0.15 nf=4
Xpre_x x clk vdd vdd sky130_fd_pr__pfet_01v8 w=8 l=0.15 nf=4
Xpre_y y clk vdd vdd sky130_fd_pr__pfet_01v8 w=8 l=0.15 nf=4
Xq_p1 q x vdd vdd sky130_fd_pr__pfet_01v8 w=8 l=0.15 nf=4
Xq_p2 q qb vdd vdd sky130_fd_pr__pfet_01v8 w=8 l=0.15 nf=4
Xq_n1 q x q_series 0 sky130_fd_pr__nfet_01v8 w=8 l=0.15 nf=4
Xq_n2 q_series qb 0 0 sky130_fd_pr__nfet_01v8 w=8 l=0.15 nf=4
Xqb_p1 qb y vdd vdd sky130_fd_pr__pfet_01v8 w=8 l=0.15 nf=4
Xqb_p2 qb q vdd vdd sky130_fd_pr__pfet_01v8 w=8 l=0.15 nf=4
Xqb_n1 qb y qb_series 0 sky130_fd_pr__nfet_01v8 w=8 l=0.15 nf=4
Xqb_n2 qb_series q 0 0 sky130_fd_pr__nfet_01v8 w=8 l=0.15 nf=4
.control
set noaskquit
set numdgt=15
tran 1p 7.6e-09 0 1p
wrdata trace.txt v(clk) v(inp) v(inn) v(x) v(y) v(q) v(qb) i(vdd) i(vclk) i(vinp) i(vinn)
quit
.endc
.end
