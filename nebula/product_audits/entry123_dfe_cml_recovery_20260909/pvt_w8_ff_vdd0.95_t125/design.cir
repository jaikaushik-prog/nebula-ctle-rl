* Entry 122 CML master/slave; external differential clock, no feedback DAC
.lib "C:/Users/DELL/Desktop/serdes-dsp-framework-main/nebula/device/spice/pdk_trim/sections/sky130_ctle__ff.lib.spice" ff
.temp 125
Vdd vdd 0 1.71
Vclk clk 0 PULSE(0.57 1.14 3e-10 1e-11 1e-11 8.000000000000001e-11 2e-10)
Vclkb clkb 0 PULSE(1.14 0.57 3e-10 1e-11 1e-11 8.000000000000001e-11 2e-10)
Vinp inp 0 PWL(
+ 0 1.185944383111408
+ 4e-10 1.185944383111408
+ 4.02e-10 1.235944383111408
+ 6e-10 1.235944383111408
+ 6.02e-10 1.185944383111408
+ 8e-10 1.185944383111408
+ 8.02e-10 1.235944383111408
+ 1e-09 1.235944383111408
+ 1.002e-09 1.185944383111408
+ 1.2e-09 1.185944383111408
+ 1.202e-09 1.185944383111408
+ 1.4e-09 1.185944383111408
+ 1.402e-09 1.235944383111408
+ 1.6e-09 1.235944383111408
+ 1.602e-09 1.235944383111408
+ 1.8e-09 1.235944383111408
+ 1.802e-09 1.185944383111408
+ 2e-09 1.185944383111408
+ 2.002e-09 1.235944383111408
+ 2.2e-09 1.235944383111408
+ 2.202e-09 1.185944383111408
+ 2.4e-09 1.185944383111408
+ 2.402e-09 1.235944383111408
+ 2.6e-09 1.235944383111408
+ 2.602e-09 1.185944383111408
+ 2.8e-09 1.185944383111408
+ 2.802e-09 1.235944383111408
+ 3e-09 1.235944383111408
+ 3.002e-09 1.235944383111408
+ 3.2e-09 1.235944383111408
+ 3.202e-09 1.235944383111408
+ 3.4e-09 1.235944383111408
+ 3.402e-09 1.185944383111408
+ 3.6e-09 1.185944383111408
+ 3.602e-09 1.185944383111408
+ 3.8e-09 1.185944383111408
+ 3.802e-09 1.235944383111408
+ 4e-09 1.235944383111408
+ 4.002e-09 1.235944383111408
+ 4.2e-09 1.235944383111408
+ 4.202e-09 1.185944383111408
+ 4.400000000000001e-09 1.185944383111408
+ 4.402e-09 1.185944383111408
+ 4.6e-09 1.185944383111408
+ 4.602e-09 1.235944383111408
+ 4.8e-09 1.235944383111408
+ 4.802e-09 1.185944383111408
+ 5e-09 1.185944383111408
+ 5.002e-09 1.185944383111408
+ 5.2e-09 1.185944383111408
+ 5.202e-09 1.235944383111408
+ 5.4e-09 1.235944383111408
+ 5.402e-09 1.185944383111408
+ 5.600000000000001e-09 1.185944383111408
+ 5.602e-09 1.185944383111408
+ 5.8e-09 1.185944383111408
+ 5.802e-09 1.235944383111408
+ 6e-09 1.235944383111408
+ 6.002e-09 1.235944383111408
+ 6.2e-09 1.235944383111408
+ 6.202e-09 1.185944383111408
+ 6.4e-09 1.185944383111408
+ 6.402e-09 1.185944383111408
+ 6.6e-09 1.185944383111408
+ 6.602e-09 1.235944383111408
+ 6.800000000000001e-09 1.235944383111408
+ 6.802e-09 1.235944383111408
+ 7.000000000000001e-09 1.235944383111408
+ 7.002e-09 1.235944383111408
+ 7.2e-09 1.235944383111408
+ 7.202e-09 1.235944383111408
+ 7.6e-09 1.235944383111408
+ )
Vinn inn 0 PWL(
+ 0 1.235944383111408
+ 4e-10 1.235944383111408
+ 4.02e-10 1.185944383111408
+ 6e-10 1.185944383111408
+ 6.02e-10 1.235944383111408
+ 8e-10 1.235944383111408
+ 8.02e-10 1.185944383111408
+ 1e-09 1.185944383111408
+ 1.002e-09 1.235944383111408
+ 1.2e-09 1.235944383111408
+ 1.202e-09 1.235944383111408
+ 1.4e-09 1.235944383111408
+ 1.402e-09 1.185944383111408
+ 1.6e-09 1.185944383111408
+ 1.602e-09 1.185944383111408
+ 1.8e-09 1.185944383111408
+ 1.802e-09 1.235944383111408
+ 2e-09 1.235944383111408
+ 2.002e-09 1.185944383111408
+ 2.2e-09 1.185944383111408
+ 2.202e-09 1.235944383111408
+ 2.4e-09 1.235944383111408
+ 2.402e-09 1.185944383111408
+ 2.6e-09 1.185944383111408
+ 2.602e-09 1.235944383111408
+ 2.8e-09 1.235944383111408
+ 2.802e-09 1.185944383111408
+ 3e-09 1.185944383111408
+ 3.002e-09 1.185944383111408
+ 3.2e-09 1.185944383111408
+ 3.202e-09 1.185944383111408
+ 3.4e-09 1.185944383111408
+ 3.402e-09 1.235944383111408
+ 3.6e-09 1.235944383111408
+ 3.602e-09 1.235944383111408
+ 3.8e-09 1.235944383111408
+ 3.802e-09 1.185944383111408
+ 4e-09 1.185944383111408
+ 4.002e-09 1.185944383111408
+ 4.2e-09 1.185944383111408
+ 4.202e-09 1.235944383111408
+ 4.400000000000001e-09 1.235944383111408
+ 4.402e-09 1.235944383111408
+ 4.6e-09 1.235944383111408
+ 4.602e-09 1.185944383111408
+ 4.8e-09 1.185944383111408
+ 4.802e-09 1.235944383111408
+ 5e-09 1.235944383111408
+ 5.002e-09 1.235944383111408
+ 5.2e-09 1.235944383111408
+ 5.202e-09 1.185944383111408
+ 5.4e-09 1.185944383111408
+ 5.402e-09 1.235944383111408
+ 5.600000000000001e-09 1.235944383111408
+ 5.602e-09 1.235944383111408
+ 5.8e-09 1.235944383111408
+ 5.802e-09 1.185944383111408
+ 6e-09 1.185944383111408
+ 6.002e-09 1.185944383111408
+ 6.2e-09 1.185944383111408
+ 6.202e-09 1.235944383111408
+ 6.4e-09 1.235944383111408
+ 6.402e-09 1.235944383111408
+ 6.6e-09 1.235944383111408
+ 6.602e-09 1.185944383111408
+ 6.800000000000001e-09 1.185944383111408
+ 6.802e-09 1.185944383111408
+ 7.000000000000001e-09 1.185944383111408
+ 7.002e-09 1.185944383111408
+ 7.2e-09 1.185944383111408
+ 7.202e-09 1.185944383111408
+ 7.6e-09 1.185944383111408
+ )
Xmip mn inp ma 0 sky130_fd_pr__nfet_01v8 w=8 l=0.15 nf=4
Xmin mp inn ma 0 sky130_fd_pr__nfet_01v8 w=8 l=0.15 nf=4
Xmrp mp mn mb 0 sky130_fd_pr__nfet_01v8 w=8 l=0.15 nf=4
Xmrn mn mp mb 0 sky130_fd_pr__nfet_01v8 w=8 l=0.15 nf=4
Xmtrack ma clkb mtail 0 sky130_fd_pr__nfet_01v8 w=8 l=0.15 nf=4
Xmhold mb clk mtail 0 sky130_fd_pr__nfet_01v8 w=8 l=0.15 nf=4
Xmtail mtail nbias 0 0 sky130_fd_pr__nfet_01v8 w=20 l=0.5 nf=10
Xsip qb mp sa 0 sky130_fd_pr__nfet_01v8 w=8 l=0.15 nf=4
Xsin q mn sa 0 sky130_fd_pr__nfet_01v8 w=8 l=0.15 nf=4
Xsrp q qb sb 0 sky130_fd_pr__nfet_01v8 w=8 l=0.15 nf=4
Xsrn qb q sb 0 sky130_fd_pr__nfet_01v8 w=8 l=0.15 nf=4
Xstrack sa clk stail 0 sky130_fd_pr__nfet_01v8 w=8 l=0.15 nf=4
Xshold sb clkb stail 0 sky130_fd_pr__nfet_01v8 w=8 l=0.15 nf=4
Xstail stail nbias 0 0 sky130_fd_pr__nfet_01v8 w=20 l=0.5 nf=10
Xref nbias nbias 0 0 sky130_fd_pr__nfet_01v8 w=4 l=0.5 nf=2
XR_mp vdd mp 0 sky130_fd_pr__res_high_po w=1 l=1.33 m=1
XR_mn vdd mn 0 sky130_fd_pr__res_high_po w=1 l=1.33 m=1
XR_q vdd q 0 sky130_fd_pr__res_high_po w=1 l=1.33 m=1
XR_qb vdd qb 0 sky130_fd_pr__res_high_po w=1 l=1.33 m=1
XR_nbias vdd nbias 0 sky130_fd_pr__res_high_po w=1 l=30.33 m=1
.control
set noaskquit
set numdgt=15
tran 1p 7.6e-09 0 1p
wrdata trace.txt v(clk) v(clkb) v(inp) v(inn) v(mp) v(mn) v(q) v(qb) i(vdd) i(vclk) i(vclkb) i(vinp) i(vinn)
wrdata terminals.txt v(clk) v(clkb) v(inn) v(inp) v(ma) v(mb) v(mn) v(mp) v(mtail) v(nbias) v(q) v(qb) v(sa) v(sb) v(stail)
quit
.endc
.end
