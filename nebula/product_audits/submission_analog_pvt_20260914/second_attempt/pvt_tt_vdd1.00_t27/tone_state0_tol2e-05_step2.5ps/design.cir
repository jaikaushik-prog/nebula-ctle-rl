* nebula sky130 sizing point (auto-generated; do not edit by hand)
.lib "C:/Users/DELL/sky130A/libs.tech/ngspice/sky130.lib.spice" tt
.temp 27

.param W=57.97671772296124 L=0.3911493163378813 NF=4
.param RL=254.6329712064977 IT=0.001813449296655868 CL=3.262805963205924e-14
.param VDD=1.8 VCM=1.5010229732197666

Vdd   vdd 0 {VDD}
Vcm   cm  0 {VCM}

* One swept/AC source, two VCVSs: v(inp,inn) == v(vid) exactly. This makes the
* .noise input reference DIFFERENTIAL (see the module docstring) and lets .dc
* sweep the differential input directly.
Vid vid 0 DC 0 AC 1 SIN(0 0.1 100meg)
Einp  inx cm vid 0 0.5
Einn  iny cm vid 0 -0.5
* Input attenuator (D16), code 7 of 7: A = 0.4315 (7.30 dB).
* Explicit diagnostic/historical range: 2.31739x.
* Production D16 default: 2.31739x maximum.
Xatt_sp inx inp 0 sky130_fd_pr__res_high_po w=10 l=3.41
Xatt_sn iny inn 0 sky130_fd_pr__res_high_po w=10 l=3.41
Xatt_rp0 inp att_p0 0 sky130_fd_pr__res_high_po w=8 l=16.22
Xatt_swp0 att_p0 0 cm vdd sky130_fd_pr__pfet_01v8 W=40 L=0.15 nf=1
Xatt_rn0 inn att_n0 0 sky130_fd_pr__res_high_po w=8 l=16.22
Xatt_swn0 att_n0 0 cm vdd sky130_fd_pr__pfet_01v8 W=40 L=0.15 nf=1
Xatt_rp1 inp att_p1 0 sky130_fd_pr__res_high_po w=5.73 l=4.97
Xatt_swp1 att_p1 0 cm vdd sky130_fd_pr__pfet_01v8 W=80 L=0.15 nf=2
Xatt_rn1 inn att_n1 0 sky130_fd_pr__res_high_po w=5.73 l=4.97
Xatt_swn1 att_n1 0 cm vdd sky130_fd_pr__pfet_01v8 W=80 L=0.15 nf=2
Xatt_rp2 inp att_p2 0 sky130_fd_pr__res_high_po w=5.73 l=4.97 m=2
Xatt_swp2 att_p2 0 cm vdd sky130_fd_pr__pfet_01v8 W=160 L=0.15 nf=4
Xatt_rn2 inn att_n2 0 sky130_fd_pr__res_high_po w=5.73 l=4.97 m=2
Xatt_swn2 att_n2 0 cm vdd sky130_fd_pr__pfet_01v8 W=160 L=0.15 nf=4

XM1   outp inp s1 0 sky130_fd_pr__nfet_01v8 W={W} L={L} nf={NF}
XM2   outn inn s2 0 sky130_fd_pr__nfet_01v8 W={W} L={L} nf={NF}

* Load resistors: SKY130 poly, drawn geometry from passives.to_geometry().
* Third terminal is the substrate -- it carries the res_po bottom-plate
* parasitic, half of which lands on the output node (PASSIVES.md 4.4).
Xrlp  vdd outp 0 sky130_fd_pr__res_high_po w=10 l=14.745 m=2
Xrln  vdd outn 0 sky130_fd_pr__res_high_po w=10 l=14.745 m=2

* Degeneration, between the two SOURCES (the /2 in k = 1 + (gm+gmbs)*Rs/2).
* MIM: two terminals, no bulk node -- the model carries no bottom plate at all
* (PASSIVES.md 4.4), which is a modelling absence, not a physical one.

* Current-mirror tail. N = W_tail/W_ref = 8; the reference device is one
* unit of the same finger width, so the mirror ratio is set by geometry and not
* by a voltage that would drift against vth across corners.
.param WT=201.656 LT=0.5 NFT=8
.param WREF=25.2069 NFREF=1 IREF=0.000226681162 CBYP=1e-11

* Physical supply-dependent reference prototype, not a precision reference.
* IREF is the nominal sizing target below, not an ideal current source.
Xbpref p_bias p_bias vdd vdd sky130_fd_pr__pfet_01v8 W=25.2069 L=0.5 nf=1
Xbpfeed nbias p_bias vdd vdd sky130_fd_pr__pfet_01v8 W=25.2069 L=0.5 nf=1
Xrbias p_bias 0 0 sky130_fd_pr__res_high_po w=1 l=5.34 m=1
XMR   nbias nbias 0 0 sky130_fd_pr__nfet_01v8 W={WREF} L={LT} nf={NFREF}
XMT1  s1    nbias 0 0 sky130_fd_pr__nfet_01v8 W={WT} L={LT} nf={NFT}
XMT2  s2    nbias 0 0 sky130_fd_pr__nfet_01v8 W={WT} L={LT} nf={NFT}
* Physical MIM bypass; body/plate area is counted, layout remains unverified.
Xcbyp nbias 0 sky130_fd_pr__cap_mim_m3_1 w=70.545 l=70.545 m=1

CLp   outp 0 {CL}
CLn   outn 0 {CL}

* Entry 124: real current summer, CML decision memory, switched-current DAC
Vdfclk df_clk 0 PULSE(0.6 1.2 6e-10 1e-11 1e-11 8.000000000000001e-11 2e-10)
Vdfclkb df_clkb 0 PULSE(1.2 0.6 6e-10 1e-11 1e-11 8.000000000000001e-11 2e-10)
Vtap0 tap0 0 0
Vtap1 tap1 0 1.8
Vtap2 tap2 0 0
Vtap3 tap3 0 0
Xdf_mip df_mn sum_p df_ma 0 sky130_fd_pr__nfet_01v8 w=8 l=0.15 nf=4
Xdf_min df_mp sum_n df_ma 0 sky130_fd_pr__nfet_01v8 w=8 l=0.15 nf=4
Xdf_mrp df_mp df_mn df_mb 0 sky130_fd_pr__nfet_01v8 w=8 l=0.15 nf=4
Xdf_mrn df_mn df_mp df_mb 0 sky130_fd_pr__nfet_01v8 w=8 l=0.15 nf=4
Xdf_mtrack df_ma df_clkb df_mtail 0 sky130_fd_pr__nfet_01v8 w=8 l=0.15 nf=4
Xdf_mhold df_mb df_clk df_mtail 0 sky130_fd_pr__nfet_01v8 w=8 l=0.15 nf=4
Xdf_mtail df_mtail df_nbias 0 0 sky130_fd_pr__nfet_01v8 w=20 l=0.5 nf=10
Xdf_sip df_qb df_mp df_sa 0 sky130_fd_pr__nfet_01v8 w=8 l=0.15 nf=4
Xdf_sin df_q df_mn df_sa 0 sky130_fd_pr__nfet_01v8 w=8 l=0.15 nf=4
Xdf_srp df_q df_qb df_sb 0 sky130_fd_pr__nfet_01v8 w=8 l=0.15 nf=4
Xdf_srn df_qb df_q df_sb 0 sky130_fd_pr__nfet_01v8 w=8 l=0.15 nf=4
Xdf_strack df_sa df_clk df_stail 0 sky130_fd_pr__nfet_01v8 w=8 l=0.15 nf=4
Xdf_shold df_sb df_clkb df_stail 0 sky130_fd_pr__nfet_01v8 w=8 l=0.15 nf=4
Xdf_stail df_stail df_nbias 0 0 sky130_fd_pr__nfet_01v8 w=20 l=0.5 nf=10
Xdf_ref df_nbias df_nbias 0 0 sky130_fd_pr__nfet_01v8 w=4 l=0.5 nf=2
Xdfe_sump sum_n outn sum_tail 0 sky130_fd_pr__nfet_01v8 w=8 l=0.15 nf=4
Xdfe_sumn sum_p outp sum_tail 0 sky130_fd_pr__nfet_01v8 w=8 l=0.15 nf=4
Xdfe_sumtail sum_tail df_nbias 0 0 sky130_fd_pr__nfet_01v8 w=20 l=0.5 nf=10
Xdfe_dacp sum_p df_q fd_common 0 sky130_fd_pr__nfet_01v8 w=2 l=0.15 nf=1
Xdfe_dacn sum_n df_qb fd_common 0 sky130_fd_pr__nfet_01v8 w=2 l=0.15 nf=1
Xdfe_tail0 fd_common df_nbias fd_tail0 0 sky130_fd_pr__nfet_01v8 w=1 l=0.5 nf=1
Xdfe_en0 fd_tail0 tap0 0 0 sky130_fd_pr__nfet_01v8 w=8 l=0.15 nf=4
Xdfe_tail1 fd_common df_nbias fd_tail1 0 sky130_fd_pr__nfet_01v8 w=2 l=0.5 nf=1
Xdfe_en1 fd_tail1 tap1 0 0 sky130_fd_pr__nfet_01v8 w=8 l=0.15 nf=4
Xdfe_tail2 fd_common df_nbias fd_tail2 0 sky130_fd_pr__nfet_01v8 w=4 l=0.5 nf=2
Xdfe_en2 fd_tail2 tap2 0 0 sky130_fd_pr__nfet_01v8 w=8 l=0.15 nf=4
Xdfe_tail3 fd_common df_nbias fd_tail3 0 sky130_fd_pr__nfet_01v8 w=8 l=0.5 nf=4
Xdfe_en3 fd_tail3 tap3 0 0 sky130_fd_pr__nfet_01v8 w=8 l=0.15 nf=4
Xdf_R_mp vdd df_mp 0 sky130_fd_pr__res_high_po w=1 l=1.33 m=1
Xdf_R_mn vdd df_mn 0 sky130_fd_pr__res_high_po w=1 l=1.33 m=1
Xdf_R_q vdd df_q 0 sky130_fd_pr__res_high_po w=1 l=1.33 m=1
Xdf_R_qb vdd df_qb 0 sky130_fd_pr__res_high_po w=1 l=1.33 m=1
Xdf_R_nbias vdd df_nbias 0 sky130_fd_pr__res_high_po w=1 l=30.33 m=1
Xdfe_Rsum_p vdd sum_p 0 sky130_fd_pr__res_high_po w=1 l=1.33 m=1
Xdfe_Rsum_n vdd sum_n 0 sky130_fd_pr__res_high_po w=1 l=1.33 m=1
* Entry 125 physical off-branch bleeders
Xdfe_bleed0 fd_tail0 df_nbias 0 0 sky130_fd_pr__nfet_01v8 w=0.42 l=4 nf=1
Xdfe_bleed1 fd_tail1 df_nbias 0 0 sky130_fd_pr__nfet_01v8 w=0.42 l=4 nf=1
Xdfe_bleed2 fd_tail2 df_nbias 0 0 sky130_fd_pr__nfet_01v8 w=0.42 l=4 nf=1
Xdfe_bleed3 fd_tail3 df_nbias 0 0 sky130_fd_pr__nfet_01v8 w=0.42 l=4 nf=1
Xrc_rmax s1 s2 0 sky130_fd_pr__res_high_po w=2.85 l=4.865
Xrc_branch s1 rc_mid 0 sky130_fd_pr__res_high_po w=10 l=2.645 m=2
Xrc_switch rc_mid rc_gate s2 0 sky130_fd_pr__nfet_01v8 W=80 L=0.15 nf=2
Xrc_rfeed rctrl rc_gate 0 sky130_fd_pr__res_high_po w=1.41 l=43.23
Xrc_cfeed cctrl rc_ct 0 sky130_fd_pr__res_high_po w=1.41 l=43.23
Xrc_rbypass rc_gate 0 sky130_fd_pr__cap_mim_m3_1 w=22.195 l=22.195
Xrc_cbypass rc_ct 0 sky130_fd_pr__cap_mim_m3_1 w=70.545 l=70.545
Xrc_var_s1 s1 rc_ct 0 sky130_fd_pr__cap_var_lvt w=5 l=0.5 vm=1 m=500
Xrc_var_s2 s2 rc_ct 0 sky130_fd_pr__cap_var_lvt w=5 l=0.5 vm=1 m=500
VrcR rctrl 0 1.26
VrcC cctrl 0 0.333
.options reltol=2e-05 vntol=1e-7 abstol=1e-12
.nodeset v(df_q)=1.515592436789362 v(df_qb)=1.7897858537716 v(df_mp)=1.515596206618831 v(df_mn)=1.7897821704968
.options method=gear maxord=2
.control
set noaskquit
set numdgt=15
set wr_singlescale
unset sqrnoise
tran 2.5e-12 150n 0 2.5e-12
wrdata trace.txt v(df_clk) v(df_clkb) v(vid) v(sum_p) v(sum_n) v(df_q) v(df_qb) i(vdd) i(vdfclk) i(vdfclkb) i(vid) v(outp) v(outn) i(vcm) v(tap0) i(vtap0) v(tap1) i(vtap1) v(tap2) i(vtap2) v(tap3) i(vtap3) v(cm) v(df_mp) v(df_mn) v(rctrl) v(cctrl) v(rc_gate) v(rc_ct) i(vrcr) i(vrcc)
wrdata terminals.txt v(att_n0) v(att_n1) v(att_n2) v(att_p0) v(att_p1) v(att_p2) v(cctrl) v(cm) v(df_clk) v(df_clkb) v(df_ma) v(df_mb) v(df_mn) v(df_mp) v(df_mtail) v(df_nbias) v(df_q) v(df_qb) v(df_sa) v(df_sb) v(df_stail) v(fd_common) v(fd_tail0) v(fd_tail1) v(fd_tail2) v(fd_tail3) v(inn) v(inp) v(nbias) v(outn) v(outp) v(p_bias) v(rc_ct) v(rc_gate) v(rc_mid) v(rctrl) v(s1) v(s2) v(sum_n) v(sum_p) v(sum_tail) v(tap0) v(tap1) v(tap2) v(tap3) v(vdd) v(vid)
quit
.endc
.end
