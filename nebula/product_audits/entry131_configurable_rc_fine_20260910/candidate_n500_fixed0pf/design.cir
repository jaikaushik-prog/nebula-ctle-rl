* Entry 128 physical configurable RC screening, standalone CTLE
.lib "C:/Users/DELL/sky130A/libs.tech/ngspice/sky130.lib.spice" tt
.temp 27
.subckt rc_fixed inx iny cm vdd outp outn rctrl cctrl
.param W=57.97671772296124 L=0.3911493163378813 NF=4
.param RL=254.6329712064977 RS=356.81770148453967 CS=2.8515485554341908e-12 IT=0.001813449296655868 CL=3.262805963205924e-14
.param VDD=1.8 VCM=1.5010229732197666
Xatt_sp inx inp 0 sky130_fd_pr__res_high_po w=10 l=3.41
Xatt_sn iny inn 0 sky130_fd_pr__res_high_po w=10 l=3.41
Xatt_rp0 inp att_p0 0 sky130_fd_pr__res_high_po w=8 l=16.22
Xatt_swp0 att_p0 0 cm vdd sky130_fd_pr__pfet_01v8 W=40 L=0.15 nf=1
Xatt_rn0 inn att_n0 0 sky130_fd_pr__res_high_po w=8 l=16.22
Xatt_swn0 att_n0 0 cm vdd sky130_fd_pr__pfet_01v8 W=40 L=0.15 nf=1
Xatt_rp1 inp att_p1 0 sky130_fd_pr__res_high_po w=5.73 l=4.97
Xatt_swp1 att_p1 0 cm vdd sky130_fd_pr__pfet_01v8 W=80 L=0.15 nf=2
Xatt_rn1 inn att_n1 0 sky130_fd_pr__res_high_po w=5.73 l=4.97
Xatt_swn1 att_n1 0 cm vdd sky130_fd_pr__pfet_01v8 W=80 L=0.15 nf=2
Xatt_rp2 inp att_p2 0 sky130_fd_pr__res_high_po w=5.73 l=4.97 m=2
Xatt_swp2 att_p2 0 cm vdd sky130_fd_pr__pfet_01v8 W=160 L=0.15 nf=4
Xatt_rn2 inn att_n2 0 sky130_fd_pr__res_high_po w=5.73 l=4.97 m=2
Xatt_swn2 att_n2 0 cm vdd sky130_fd_pr__pfet_01v8 W=160 L=0.15 nf=4
XM1   outp inp s1 0 sky130_fd_pr__nfet_01v8 W={W} L={L} nf={NF}
XM2   outn inn s2 0 sky130_fd_pr__nfet_01v8 W={W} L={L} nf={NF}
Xrlp  vdd outp 0 sky130_fd_pr__res_high_po w=10 l=14.745 m=2
Xrln  vdd outn 0 sky130_fd_pr__res_high_po w=10 l=14.745 m=2
Xrs   s1 s2 0 sky130_fd_pr__res_high_po w=2 l=0.99
Xcs   s1 s2 sky130_fd_pr__cap_mim_m3_1 w=37.595 l=37.595
.param WT=201.656 LT=0.5 NFT=8
.param WREF=25.2069 NFREF=1 IREF=0.000226681162 CBYP=1e-11
Xbpref p_bias p_bias vdd vdd sky130_fd_pr__pfet_01v8 W=25.2069 L=0.5 nf=1
Xbpfeed nbias p_bias vdd vdd sky130_fd_pr__pfet_01v8 W=25.2069 L=0.5 nf=1
Xrbias p_bias 0 0 sky130_fd_pr__res_high_po w=1 l=5.34 m=1
XMR   nbias nbias 0 0 sky130_fd_pr__nfet_01v8 W={WREF} L={LT} nf={NFREF}
XMT1  s1    nbias 0 0 sky130_fd_pr__nfet_01v8 W={WT} L={LT} nf={NFT}
XMT2  s2    nbias 0 0 sky130_fd_pr__nfet_01v8 W={WT} L={LT} nf={NFT}
Xcbyp nbias 0 sky130_fd_pr__cap_mim_m3_1 w=70.545 l=70.545 m=1
CLp   outp 0 {CL}
CLn   outn 0 {CL}
.ends rc_fixed
.subckt rc_tuned inx iny cm vdd outp outn rctrl cctrl
.param W=57.97671772296124 L=0.3911493163378813 NF=4
.param RL=254.6329712064977 IT=0.001813449296655868 CL=3.262805963205924e-14
.param VDD=1.8 VCM=1.5010229732197666
Xatt_sp inx inp 0 sky130_fd_pr__res_high_po w=10 l=3.41
Xatt_sn iny inn 0 sky130_fd_pr__res_high_po w=10 l=3.41
Xatt_rp0 inp att_p0 0 sky130_fd_pr__res_high_po w=8 l=16.22
Xatt_swp0 att_p0 0 cm vdd sky130_fd_pr__pfet_01v8 W=40 L=0.15 nf=1
Xatt_rn0 inn att_n0 0 sky130_fd_pr__res_high_po w=8 l=16.22
Xatt_swn0 att_n0 0 cm vdd sky130_fd_pr__pfet_01v8 W=40 L=0.15 nf=1
Xatt_rp1 inp att_p1 0 sky130_fd_pr__res_high_po w=5.73 l=4.97
Xatt_swp1 att_p1 0 cm vdd sky130_fd_pr__pfet_01v8 W=80 L=0.15 nf=2
Xatt_rn1 inn att_n1 0 sky130_fd_pr__res_high_po w=5.73 l=4.97
Xatt_swn1 att_n1 0 cm vdd sky130_fd_pr__pfet_01v8 W=80 L=0.15 nf=2
Xatt_rp2 inp att_p2 0 sky130_fd_pr__res_high_po w=5.73 l=4.97 m=2
Xatt_swp2 att_p2 0 cm vdd sky130_fd_pr__pfet_01v8 W=160 L=0.15 nf=4
Xatt_rn2 inn att_n2 0 sky130_fd_pr__res_high_po w=5.73 l=4.97 m=2
Xatt_swn2 att_n2 0 cm vdd sky130_fd_pr__pfet_01v8 W=160 L=0.15 nf=4
XM1   outp inp s1 0 sky130_fd_pr__nfet_01v8 W={W} L={L} nf={NF}
XM2   outn inn s2 0 sky130_fd_pr__nfet_01v8 W={W} L={L} nf={NF}
Xrlp  vdd outp 0 sky130_fd_pr__res_high_po w=10 l=14.745 m=2
Xrln  vdd outn 0 sky130_fd_pr__res_high_po w=10 l=14.745 m=2
.param WT=201.656 LT=0.5 NFT=8
.param WREF=25.2069 NFREF=1 IREF=0.000226681162 CBYP=1e-11
Xbpref p_bias p_bias vdd vdd sky130_fd_pr__pfet_01v8 W=25.2069 L=0.5 nf=1
Xbpfeed nbias p_bias vdd vdd sky130_fd_pr__pfet_01v8 W=25.2069 L=0.5 nf=1
Xrbias p_bias 0 0 sky130_fd_pr__res_high_po w=1 l=5.34 m=1
XMR   nbias nbias 0 0 sky130_fd_pr__nfet_01v8 W={WREF} L={LT} nf={NFREF}
XMT1  s1    nbias 0 0 sky130_fd_pr__nfet_01v8 W={WT} L={LT} nf={NFT}
XMT2  s2    nbias 0 0 sky130_fd_pr__nfet_01v8 W={WT} L={LT} nf={NFT}
Xcbyp nbias 0 sky130_fd_pr__cap_mim_m3_1 w=70.545 l=70.545 m=1
CLp   outp 0 {CL}
CLn   outn 0 {CL}
Xrc_rmax s1 s2 0 sky130_fd_pr__res_high_po w=2.85 l=4.865
Xrc_branch s1 rc_mid 0 sky130_fd_pr__res_high_po w=10 l=2.645 m=2
Xrc_switch rc_mid rc_gate s2 0 sky130_fd_pr__nfet_01v8 W=80 L=0.15 nf=2
Xrc_rfeed rctrl rc_gate 0 sky130_fd_pr__res_high_po w=1.41 l=43.23
Xrc_cfeed cctrl rc_ct 0 sky130_fd_pr__res_high_po w=1.41 l=43.23
Xrc_rbypass rc_gate 0 sky130_fd_pr__cap_mim_m3_1 w=22.195 l=22.195
Xrc_cbypass rc_ct 0 sky130_fd_pr__cap_mim_m3_1 w=70.545 l=70.545
Xrc_var_s1 s1 rc_ct 0 sky130_fd_pr__cap_var_lvt w=5 l=0.5 vm=1 m=500
Xrc_var_s2 s2 rc_ct 0 sky130_fd_pr__cap_var_lvt w=5 l=0.5 vm=1 m=500
.ends rc_tuned
Vsupply0 vdd0 0 1.8
Vcm0 cm0 0 1.501022973219767
Vid0 vid0 0 dc 0 ac 1
Einp0 inx0 cm0 vid0 0 0.5
Einn0 iny0 cm0 vid0 0 -0.5
Vr0 rctrl0 0 0
Vc0 cctrl0 0 0
Xcase0 inx0 iny0 cm0 vdd0 outp0 outn0 rctrl0 cctrl0 rc_tuned
Vsupply81 vdd81 0 1.8
Vcm81 cm81 0 1.501022973219767
Vid81 vid81 0 dc 0 ac 1
Einp81 inx81 cm81 vid81 0 0.5
Einn81 iny81 cm81 vid81 0 -0.5
Vr81 rctrl81 0 0
Vc81 cctrl81 0 0
Xcase81 inx81 iny81 cm81 vdd81 outp81 outn81 rctrl81 cctrl81 rc_fixed
.options reltol=1e-9 vntol=1e-12 abstol=1e-15
.control
set noaskquit
set numdgt=15
set wr_singlescale
alter Vr0 1.17
alter Vc0 0
op
wrdata op_000.txt i(vsupply0) v(xcase0.att_n0) v(xcase0.att_n1) v(xcase0.att_n2) v(xcase0.att_p0) v(xcase0.att_p1) v(xcase0.att_p2) v(cctrl0) v(cm0) v(xcase0.inn) v(xcase0.inp) v(inx0) v(iny0) v(xcase0.nbias) v(outn0) v(outp0) v(xcase0.p_bias) v(xcase0.rc_ct) v(xcase0.rc_gate) v(xcase0.rc_mid) v(rctrl0) v(xcase0.s1) v(xcase0.s2) v(vdd0) i(vsupply81) v(xcase81.att_n0) v(xcase81.att_n1) v(xcase81.att_n2) v(xcase81.att_p0) v(xcase81.att_p1) v(xcase81.att_p2) v(cctrl81) v(cm81) v(xcase81.inn) v(xcase81.inp) v(inx81) v(iny81) v(xcase81.nbias) v(outn81) v(outp81) v(xcase81.p_bias) v(rctrl81) v(xcase81.s1) v(xcase81.s2) v(vdd81)
ac dec 50 1meg 100g
wrdata ac_000.txt v(outp0) v(outn0) v(vid0) v(outp81) v(outn81) v(vid81)
alter Vr0 1.17
alter Vc0 0.027
op
wrdata op_001.txt i(vsupply0) v(xcase0.att_n0) v(xcase0.att_n1) v(xcase0.att_n2) v(xcase0.att_p0) v(xcase0.att_p1) v(xcase0.att_p2) v(cctrl0) v(cm0) v(xcase0.inn) v(xcase0.inp) v(inx0) v(iny0) v(xcase0.nbias) v(outn0) v(outp0) v(xcase0.p_bias) v(xcase0.rc_ct) v(xcase0.rc_gate) v(xcase0.rc_mid) v(rctrl0) v(xcase0.s1) v(xcase0.s2) v(vdd0) i(vsupply81) v(xcase81.att_n0) v(xcase81.att_n1) v(xcase81.att_n2) v(xcase81.att_p0) v(xcase81.att_p1) v(xcase81.att_p2) v(cctrl81) v(cm81) v(xcase81.inn) v(xcase81.inp) v(inx81) v(iny81) v(xcase81.nbias) v(outn81) v(outp81) v(xcase81.p_bias) v(rctrl81) v(xcase81.s1) v(xcase81.s2) v(vdd81)
ac dec 50 1meg 100g
wrdata ac_001.txt v(outp0) v(outn0) v(vid0) v(outp81) v(outn81) v(vid81)
alter Vr0 1.17
alter Vc0 0.054
op
wrdata op_002.txt i(vsupply0) v(xcase0.att_n0) v(xcase0.att_n1) v(xcase0.att_n2) v(xcase0.att_p0) v(xcase0.att_p1) v(xcase0.att_p2) v(cctrl0) v(cm0) v(xcase0.inn) v(xcase0.inp) v(inx0) v(iny0) v(xcase0.nbias) v(outn0) v(outp0) v(xcase0.p_bias) v(xcase0.rc_ct) v(xcase0.rc_gate) v(xcase0.rc_mid) v(rctrl0) v(xcase0.s1) v(xcase0.s2) v(vdd0) i(vsupply81) v(xcase81.att_n0) v(xcase81.att_n1) v(xcase81.att_n2) v(xcase81.att_p0) v(xcase81.att_p1) v(xcase81.att_p2) v(cctrl81) v(cm81) v(xcase81.inn) v(xcase81.inp) v(inx81) v(iny81) v(xcase81.nbias) v(outn81) v(outp81) v(xcase81.p_bias) v(rctrl81) v(xcase81.s1) v(xcase81.s2) v(vdd81)
ac dec 50 1meg 100g
wrdata ac_002.txt v(outp0) v(outn0) v(vid0) v(outp81) v(outn81) v(vid81)
alter Vr0 1.17
alter Vc0 0.081
op
wrdata op_003.txt i(vsupply0) v(xcase0.att_n0) v(xcase0.att_n1) v(xcase0.att_n2) v(xcase0.att_p0) v(xcase0.att_p1) v(xcase0.att_p2) v(cctrl0) v(cm0) v(xcase0.inn) v(xcase0.inp) v(inx0) v(iny0) v(xcase0.nbias) v(outn0) v(outp0) v(xcase0.p_bias) v(xcase0.rc_ct) v(xcase0.rc_gate) v(xcase0.rc_mid) v(rctrl0) v(xcase0.s1) v(xcase0.s2) v(vdd0) i(vsupply81) v(xcase81.att_n0) v(xcase81.att_n1) v(xcase81.att_n2) v(xcase81.att_p0) v(xcase81.att_p1) v(xcase81.att_p2) v(cctrl81) v(cm81) v(xcase81.inn) v(xcase81.inp) v(inx81) v(iny81) v(xcase81.nbias) v(outn81) v(outp81) v(xcase81.p_bias) v(rctrl81) v(xcase81.s1) v(xcase81.s2) v(vdd81)
ac dec 50 1meg 100g
wrdata ac_003.txt v(outp0) v(outn0) v(vid0) v(outp81) v(outn81) v(vid81)
alter Vr0 1.17
alter Vc0 0.108
op
wrdata op_004.txt i(vsupply0) v(xcase0.att_n0) v(xcase0.att_n1) v(xcase0.att_n2) v(xcase0.att_p0) v(xcase0.att_p1) v(xcase0.att_p2) v(cctrl0) v(cm0) v(xcase0.inn) v(xcase0.inp) v(inx0) v(iny0) v(xcase0.nbias) v(outn0) v(outp0) v(xcase0.p_bias) v(xcase0.rc_ct) v(xcase0.rc_gate) v(xcase0.rc_mid) v(rctrl0) v(xcase0.s1) v(xcase0.s2) v(vdd0) i(vsupply81) v(xcase81.att_n0) v(xcase81.att_n1) v(xcase81.att_n2) v(xcase81.att_p0) v(xcase81.att_p1) v(xcase81.att_p2) v(cctrl81) v(cm81) v(xcase81.inn) v(xcase81.inp) v(inx81) v(iny81) v(xcase81.nbias) v(outn81) v(outp81) v(xcase81.p_bias) v(rctrl81) v(xcase81.s1) v(xcase81.s2) v(vdd81)
ac dec 50 1meg 100g
wrdata ac_004.txt v(outp0) v(outn0) v(vid0) v(outp81) v(outn81) v(vid81)
alter Vr0 1.17
alter Vc0 0.135
op
wrdata op_005.txt i(vsupply0) v(xcase0.att_n0) v(xcase0.att_n1) v(xcase0.att_n2) v(xcase0.att_p0) v(xcase0.att_p1) v(xcase0.att_p2) v(cctrl0) v(cm0) v(xcase0.inn) v(xcase0.inp) v(inx0) v(iny0) v(xcase0.nbias) v(outn0) v(outp0) v(xcase0.p_bias) v(xcase0.rc_ct) v(xcase0.rc_gate) v(xcase0.rc_mid) v(rctrl0) v(xcase0.s1) v(xcase0.s2) v(vdd0) i(vsupply81) v(xcase81.att_n0) v(xcase81.att_n1) v(xcase81.att_n2) v(xcase81.att_p0) v(xcase81.att_p1) v(xcase81.att_p2) v(cctrl81) v(cm81) v(xcase81.inn) v(xcase81.inp) v(inx81) v(iny81) v(xcase81.nbias) v(outn81) v(outp81) v(xcase81.p_bias) v(rctrl81) v(xcase81.s1) v(xcase81.s2) v(vdd81)
ac dec 50 1meg 100g
wrdata ac_005.txt v(outp0) v(outn0) v(vid0) v(outp81) v(outn81) v(vid81)
alter Vr0 1.17
alter Vc0 0.162
op
wrdata op_006.txt i(vsupply0) v(xcase0.att_n0) v(xcase0.att_n1) v(xcase0.att_n2) v(xcase0.att_p0) v(xcase0.att_p1) v(xcase0.att_p2) v(cctrl0) v(cm0) v(xcase0.inn) v(xcase0.inp) v(inx0) v(iny0) v(xcase0.nbias) v(outn0) v(outp0) v(xcase0.p_bias) v(xcase0.rc_ct) v(xcase0.rc_gate) v(xcase0.rc_mid) v(rctrl0) v(xcase0.s1) v(xcase0.s2) v(vdd0) i(vsupply81) v(xcase81.att_n0) v(xcase81.att_n1) v(xcase81.att_n2) v(xcase81.att_p0) v(xcase81.att_p1) v(xcase81.att_p2) v(cctrl81) v(cm81) v(xcase81.inn) v(xcase81.inp) v(inx81) v(iny81) v(xcase81.nbias) v(outn81) v(outp81) v(xcase81.p_bias) v(rctrl81) v(xcase81.s1) v(xcase81.s2) v(vdd81)
ac dec 50 1meg 100g
wrdata ac_006.txt v(outp0) v(outn0) v(vid0) v(outp81) v(outn81) v(vid81)
alter Vr0 1.17
alter Vc0 0.189
op
wrdata op_007.txt i(vsupply0) v(xcase0.att_n0) v(xcase0.att_n1) v(xcase0.att_n2) v(xcase0.att_p0) v(xcase0.att_p1) v(xcase0.att_p2) v(cctrl0) v(cm0) v(xcase0.inn) v(xcase0.inp) v(inx0) v(iny0) v(xcase0.nbias) v(outn0) v(outp0) v(xcase0.p_bias) v(xcase0.rc_ct) v(xcase0.rc_gate) v(xcase0.rc_mid) v(rctrl0) v(xcase0.s1) v(xcase0.s2) v(vdd0) i(vsupply81) v(xcase81.att_n0) v(xcase81.att_n1) v(xcase81.att_n2) v(xcase81.att_p0) v(xcase81.att_p1) v(xcase81.att_p2) v(cctrl81) v(cm81) v(xcase81.inn) v(xcase81.inp) v(inx81) v(iny81) v(xcase81.nbias) v(outn81) v(outp81) v(xcase81.p_bias) v(rctrl81) v(xcase81.s1) v(xcase81.s2) v(vdd81)
ac dec 50 1meg 100g
wrdata ac_007.txt v(outp0) v(outn0) v(vid0) v(outp81) v(outn81) v(vid81)
alter Vr0 1.17
alter Vc0 0.216
op
wrdata op_008.txt i(vsupply0) v(xcase0.att_n0) v(xcase0.att_n1) v(xcase0.att_n2) v(xcase0.att_p0) v(xcase0.att_p1) v(xcase0.att_p2) v(cctrl0) v(cm0) v(xcase0.inn) v(xcase0.inp) v(inx0) v(iny0) v(xcase0.nbias) v(outn0) v(outp0) v(xcase0.p_bias) v(xcase0.rc_ct) v(xcase0.rc_gate) v(xcase0.rc_mid) v(rctrl0) v(xcase0.s1) v(xcase0.s2) v(vdd0) i(vsupply81) v(xcase81.att_n0) v(xcase81.att_n1) v(xcase81.att_n2) v(xcase81.att_p0) v(xcase81.att_p1) v(xcase81.att_p2) v(cctrl81) v(cm81) v(xcase81.inn) v(xcase81.inp) v(inx81) v(iny81) v(xcase81.nbias) v(outn81) v(outp81) v(xcase81.p_bias) v(rctrl81) v(xcase81.s1) v(xcase81.s2) v(vdd81)
ac dec 50 1meg 100g
wrdata ac_008.txt v(outp0) v(outn0) v(vid0) v(outp81) v(outn81) v(vid81)
alter Vr0 1.17
alter Vc0 0.243
op
wrdata op_009.txt i(vsupply0) v(xcase0.att_n0) v(xcase0.att_n1) v(xcase0.att_n2) v(xcase0.att_p0) v(xcase0.att_p1) v(xcase0.att_p2) v(cctrl0) v(cm0) v(xcase0.inn) v(xcase0.inp) v(inx0) v(iny0) v(xcase0.nbias) v(outn0) v(outp0) v(xcase0.p_bias) v(xcase0.rc_ct) v(xcase0.rc_gate) v(xcase0.rc_mid) v(rctrl0) v(xcase0.s1) v(xcase0.s2) v(vdd0) i(vsupply81) v(xcase81.att_n0) v(xcase81.att_n1) v(xcase81.att_n2) v(xcase81.att_p0) v(xcase81.att_p1) v(xcase81.att_p2) v(cctrl81) v(cm81) v(xcase81.inn) v(xcase81.inp) v(inx81) v(iny81) v(xcase81.nbias) v(outn81) v(outp81) v(xcase81.p_bias) v(rctrl81) v(xcase81.s1) v(xcase81.s2) v(vdd81)
ac dec 50 1meg 100g
wrdata ac_009.txt v(outp0) v(outn0) v(vid0) v(outp81) v(outn81) v(vid81)
alter Vr0 1.17
alter Vc0 0.27
op
wrdata op_010.txt i(vsupply0) v(xcase0.att_n0) v(xcase0.att_n1) v(xcase0.att_n2) v(xcase0.att_p0) v(xcase0.att_p1) v(xcase0.att_p2) v(cctrl0) v(cm0) v(xcase0.inn) v(xcase0.inp) v(inx0) v(iny0) v(xcase0.nbias) v(outn0) v(outp0) v(xcase0.p_bias) v(xcase0.rc_ct) v(xcase0.rc_gate) v(xcase0.rc_mid) v(rctrl0) v(xcase0.s1) v(xcase0.s2) v(vdd0) i(vsupply81) v(xcase81.att_n0) v(xcase81.att_n1) v(xcase81.att_n2) v(xcase81.att_p0) v(xcase81.att_p1) v(xcase81.att_p2) v(cctrl81) v(cm81) v(xcase81.inn) v(xcase81.inp) v(inx81) v(iny81) v(xcase81.nbias) v(outn81) v(outp81) v(xcase81.p_bias) v(rctrl81) v(xcase81.s1) v(xcase81.s2) v(vdd81)
ac dec 50 1meg 100g
wrdata ac_010.txt v(outp0) v(outn0) v(vid0) v(outp81) v(outn81) v(vid81)
alter Vr0 1.17
alter Vc0 0.297
op
wrdata op_011.txt i(vsupply0) v(xcase0.att_n0) v(xcase0.att_n1) v(xcase0.att_n2) v(xcase0.att_p0) v(xcase0.att_p1) v(xcase0.att_p2) v(cctrl0) v(cm0) v(xcase0.inn) v(xcase0.inp) v(inx0) v(iny0) v(xcase0.nbias) v(outn0) v(outp0) v(xcase0.p_bias) v(xcase0.rc_ct) v(xcase0.rc_gate) v(xcase0.rc_mid) v(rctrl0) v(xcase0.s1) v(xcase0.s2) v(vdd0) i(vsupply81) v(xcase81.att_n0) v(xcase81.att_n1) v(xcase81.att_n2) v(xcase81.att_p0) v(xcase81.att_p1) v(xcase81.att_p2) v(cctrl81) v(cm81) v(xcase81.inn) v(xcase81.inp) v(inx81) v(iny81) v(xcase81.nbias) v(outn81) v(outp81) v(xcase81.p_bias) v(rctrl81) v(xcase81.s1) v(xcase81.s2) v(vdd81)
ac dec 50 1meg 100g
wrdata ac_011.txt v(outp0) v(outn0) v(vid0) v(outp81) v(outn81) v(vid81)
alter Vr0 1.17
alter Vc0 0.324
op
wrdata op_012.txt i(vsupply0) v(xcase0.att_n0) v(xcase0.att_n1) v(xcase0.att_n2) v(xcase0.att_p0) v(xcase0.att_p1) v(xcase0.att_p2) v(cctrl0) v(cm0) v(xcase0.inn) v(xcase0.inp) v(inx0) v(iny0) v(xcase0.nbias) v(outn0) v(outp0) v(xcase0.p_bias) v(xcase0.rc_ct) v(xcase0.rc_gate) v(xcase0.rc_mid) v(rctrl0) v(xcase0.s1) v(xcase0.s2) v(vdd0) i(vsupply81) v(xcase81.att_n0) v(xcase81.att_n1) v(xcase81.att_n2) v(xcase81.att_p0) v(xcase81.att_p1) v(xcase81.att_p2) v(cctrl81) v(cm81) v(xcase81.inn) v(xcase81.inp) v(inx81) v(iny81) v(xcase81.nbias) v(outn81) v(outp81) v(xcase81.p_bias) v(rctrl81) v(xcase81.s1) v(xcase81.s2) v(vdd81)
ac dec 50 1meg 100g
wrdata ac_012.txt v(outp0) v(outn0) v(vid0) v(outp81) v(outn81) v(vid81)
alter Vr0 1.17
alter Vc0 0.351
op
wrdata op_013.txt i(vsupply0) v(xcase0.att_n0) v(xcase0.att_n1) v(xcase0.att_n2) v(xcase0.att_p0) v(xcase0.att_p1) v(xcase0.att_p2) v(cctrl0) v(cm0) v(xcase0.inn) v(xcase0.inp) v(inx0) v(iny0) v(xcase0.nbias) v(outn0) v(outp0) v(xcase0.p_bias) v(xcase0.rc_ct) v(xcase0.rc_gate) v(xcase0.rc_mid) v(rctrl0) v(xcase0.s1) v(xcase0.s2) v(vdd0) i(vsupply81) v(xcase81.att_n0) v(xcase81.att_n1) v(xcase81.att_n2) v(xcase81.att_p0) v(xcase81.att_p1) v(xcase81.att_p2) v(cctrl81) v(cm81) v(xcase81.inn) v(xcase81.inp) v(inx81) v(iny81) v(xcase81.nbias) v(outn81) v(outp81) v(xcase81.p_bias) v(rctrl81) v(xcase81.s1) v(xcase81.s2) v(vdd81)
ac dec 50 1meg 100g
wrdata ac_013.txt v(outp0) v(outn0) v(vid0) v(outp81) v(outn81) v(vid81)
alter Vr0 1.17
alter Vc0 0.378
op
wrdata op_014.txt i(vsupply0) v(xcase0.att_n0) v(xcase0.att_n1) v(xcase0.att_n2) v(xcase0.att_p0) v(xcase0.att_p1) v(xcase0.att_p2) v(cctrl0) v(cm0) v(xcase0.inn) v(xcase0.inp) v(inx0) v(iny0) v(xcase0.nbias) v(outn0) v(outp0) v(xcase0.p_bias) v(xcase0.rc_ct) v(xcase0.rc_gate) v(xcase0.rc_mid) v(rctrl0) v(xcase0.s1) v(xcase0.s2) v(vdd0) i(vsupply81) v(xcase81.att_n0) v(xcase81.att_n1) v(xcase81.att_n2) v(xcase81.att_p0) v(xcase81.att_p1) v(xcase81.att_p2) v(cctrl81) v(cm81) v(xcase81.inn) v(xcase81.inp) v(inx81) v(iny81) v(xcase81.nbias) v(outn81) v(outp81) v(xcase81.p_bias) v(rctrl81) v(xcase81.s1) v(xcase81.s2) v(vdd81)
ac dec 50 1meg 100g
wrdata ac_014.txt v(outp0) v(outn0) v(vid0) v(outp81) v(outn81) v(vid81)
alter Vr0 1.17
alter Vc0 0.405
op
wrdata op_015.txt i(vsupply0) v(xcase0.att_n0) v(xcase0.att_n1) v(xcase0.att_n2) v(xcase0.att_p0) v(xcase0.att_p1) v(xcase0.att_p2) v(cctrl0) v(cm0) v(xcase0.inn) v(xcase0.inp) v(inx0) v(iny0) v(xcase0.nbias) v(outn0) v(outp0) v(xcase0.p_bias) v(xcase0.rc_ct) v(xcase0.rc_gate) v(xcase0.rc_mid) v(rctrl0) v(xcase0.s1) v(xcase0.s2) v(vdd0) i(vsupply81) v(xcase81.att_n0) v(xcase81.att_n1) v(xcase81.att_n2) v(xcase81.att_p0) v(xcase81.att_p1) v(xcase81.att_p2) v(cctrl81) v(cm81) v(xcase81.inn) v(xcase81.inp) v(inx81) v(iny81) v(xcase81.nbias) v(outn81) v(outp81) v(xcase81.p_bias) v(rctrl81) v(xcase81.s1) v(xcase81.s2) v(vdd81)
ac dec 50 1meg 100g
wrdata ac_015.txt v(outp0) v(outn0) v(vid0) v(outp81) v(outn81) v(vid81)
alter Vr0 1.17
alter Vc0 0.432
op
wrdata op_016.txt i(vsupply0) v(xcase0.att_n0) v(xcase0.att_n1) v(xcase0.att_n2) v(xcase0.att_p0) v(xcase0.att_p1) v(xcase0.att_p2) v(cctrl0) v(cm0) v(xcase0.inn) v(xcase0.inp) v(inx0) v(iny0) v(xcase0.nbias) v(outn0) v(outp0) v(xcase0.p_bias) v(xcase0.rc_ct) v(xcase0.rc_gate) v(xcase0.rc_mid) v(rctrl0) v(xcase0.s1) v(xcase0.s2) v(vdd0) i(vsupply81) v(xcase81.att_n0) v(xcase81.att_n1) v(xcase81.att_n2) v(xcase81.att_p0) v(xcase81.att_p1) v(xcase81.att_p2) v(cctrl81) v(cm81) v(xcase81.inn) v(xcase81.inp) v(inx81) v(iny81) v(xcase81.nbias) v(outn81) v(outp81) v(xcase81.p_bias) v(rctrl81) v(xcase81.s1) v(xcase81.s2) v(vdd81)
ac dec 50 1meg 100g
wrdata ac_016.txt v(outp0) v(outn0) v(vid0) v(outp81) v(outn81) v(vid81)
alter Vr0 1.17
alter Vc0 0.459
op
wrdata op_017.txt i(vsupply0) v(xcase0.att_n0) v(xcase0.att_n1) v(xcase0.att_n2) v(xcase0.att_p0) v(xcase0.att_p1) v(xcase0.att_p2) v(cctrl0) v(cm0) v(xcase0.inn) v(xcase0.inp) v(inx0) v(iny0) v(xcase0.nbias) v(outn0) v(outp0) v(xcase0.p_bias) v(xcase0.rc_ct) v(xcase0.rc_gate) v(xcase0.rc_mid) v(rctrl0) v(xcase0.s1) v(xcase0.s2) v(vdd0) i(vsupply81) v(xcase81.att_n0) v(xcase81.att_n1) v(xcase81.att_n2) v(xcase81.att_p0) v(xcase81.att_p1) v(xcase81.att_p2) v(cctrl81) v(cm81) v(xcase81.inn) v(xcase81.inp) v(inx81) v(iny81) v(xcase81.nbias) v(outn81) v(outp81) v(xcase81.p_bias) v(rctrl81) v(xcase81.s1) v(xcase81.s2) v(vdd81)
ac dec 50 1meg 100g
wrdata ac_017.txt v(outp0) v(outn0) v(vid0) v(outp81) v(outn81) v(vid81)
alter Vr0 1.17
alter Vc0 0.486
op
wrdata op_018.txt i(vsupply0) v(xcase0.att_n0) v(xcase0.att_n1) v(xcase0.att_n2) v(xcase0.att_p0) v(xcase0.att_p1) v(xcase0.att_p2) v(cctrl0) v(cm0) v(xcase0.inn) v(xcase0.inp) v(inx0) v(iny0) v(xcase0.nbias) v(outn0) v(outp0) v(xcase0.p_bias) v(xcase0.rc_ct) v(xcase0.rc_gate) v(xcase0.rc_mid) v(rctrl0) v(xcase0.s1) v(xcase0.s2) v(vdd0) i(vsupply81) v(xcase81.att_n0) v(xcase81.att_n1) v(xcase81.att_n2) v(xcase81.att_p0) v(xcase81.att_p1) v(xcase81.att_p2) v(cctrl81) v(cm81) v(xcase81.inn) v(xcase81.inp) v(inx81) v(iny81) v(xcase81.nbias) v(outn81) v(outp81) v(xcase81.p_bias) v(rctrl81) v(xcase81.s1) v(xcase81.s2) v(vdd81)
ac dec 50 1meg 100g
wrdata ac_018.txt v(outp0) v(outn0) v(vid0) v(outp81) v(outn81) v(vid81)
alter Vr0 1.17
alter Vc0 0.513
op
wrdata op_019.txt i(vsupply0) v(xcase0.att_n0) v(xcase0.att_n1) v(xcase0.att_n2) v(xcase0.att_p0) v(xcase0.att_p1) v(xcase0.att_p2) v(cctrl0) v(cm0) v(xcase0.inn) v(xcase0.inp) v(inx0) v(iny0) v(xcase0.nbias) v(outn0) v(outp0) v(xcase0.p_bias) v(xcase0.rc_ct) v(xcase0.rc_gate) v(xcase0.rc_mid) v(rctrl0) v(xcase0.s1) v(xcase0.s2) v(vdd0) i(vsupply81) v(xcase81.att_n0) v(xcase81.att_n1) v(xcase81.att_n2) v(xcase81.att_p0) v(xcase81.att_p1) v(xcase81.att_p2) v(cctrl81) v(cm81) v(xcase81.inn) v(xcase81.inp) v(inx81) v(iny81) v(xcase81.nbias) v(outn81) v(outp81) v(xcase81.p_bias) v(rctrl81) v(xcase81.s1) v(xcase81.s2) v(vdd81)
ac dec 50 1meg 100g
wrdata ac_019.txt v(outp0) v(outn0) v(vid0) v(outp81) v(outn81) v(vid81)
alter Vr0 1.17
alter Vc0 0.54
op
wrdata op_020.txt i(vsupply0) v(xcase0.att_n0) v(xcase0.att_n1) v(xcase0.att_n2) v(xcase0.att_p0) v(xcase0.att_p1) v(xcase0.att_p2) v(cctrl0) v(cm0) v(xcase0.inn) v(xcase0.inp) v(inx0) v(iny0) v(xcase0.nbias) v(outn0) v(outp0) v(xcase0.p_bias) v(xcase0.rc_ct) v(xcase0.rc_gate) v(xcase0.rc_mid) v(rctrl0) v(xcase0.s1) v(xcase0.s2) v(vdd0) i(vsupply81) v(xcase81.att_n0) v(xcase81.att_n1) v(xcase81.att_n2) v(xcase81.att_p0) v(xcase81.att_p1) v(xcase81.att_p2) v(cctrl81) v(cm81) v(xcase81.inn) v(xcase81.inp) v(inx81) v(iny81) v(xcase81.nbias) v(outn81) v(outp81) v(xcase81.p_bias) v(rctrl81) v(xcase81.s1) v(xcase81.s2) v(vdd81)
ac dec 50 1meg 100g
wrdata ac_020.txt v(outp0) v(outn0) v(vid0) v(outp81) v(outn81) v(vid81)
alter Vr0 1.188
alter Vc0 0
op
wrdata op_021.txt i(vsupply0) v(xcase0.att_n0) v(xcase0.att_n1) v(xcase0.att_n2) v(xcase0.att_p0) v(xcase0.att_p1) v(xcase0.att_p2) v(cctrl0) v(cm0) v(xcase0.inn) v(xcase0.inp) v(inx0) v(iny0) v(xcase0.nbias) v(outn0) v(outp0) v(xcase0.p_bias) v(xcase0.rc_ct) v(xcase0.rc_gate) v(xcase0.rc_mid) v(rctrl0) v(xcase0.s1) v(xcase0.s2) v(vdd0) i(vsupply81) v(xcase81.att_n0) v(xcase81.att_n1) v(xcase81.att_n2) v(xcase81.att_p0) v(xcase81.att_p1) v(xcase81.att_p2) v(cctrl81) v(cm81) v(xcase81.inn) v(xcase81.inp) v(inx81) v(iny81) v(xcase81.nbias) v(outn81) v(outp81) v(xcase81.p_bias) v(rctrl81) v(xcase81.s1) v(xcase81.s2) v(vdd81)
ac dec 50 1meg 100g
wrdata ac_021.txt v(outp0) v(outn0) v(vid0) v(outp81) v(outn81) v(vid81)
alter Vr0 1.188
alter Vc0 0.027
op
wrdata op_022.txt i(vsupply0) v(xcase0.att_n0) v(xcase0.att_n1) v(xcase0.att_n2) v(xcase0.att_p0) v(xcase0.att_p1) v(xcase0.att_p2) v(cctrl0) v(cm0) v(xcase0.inn) v(xcase0.inp) v(inx0) v(iny0) v(xcase0.nbias) v(outn0) v(outp0) v(xcase0.p_bias) v(xcase0.rc_ct) v(xcase0.rc_gate) v(xcase0.rc_mid) v(rctrl0) v(xcase0.s1) v(xcase0.s2) v(vdd0) i(vsupply81) v(xcase81.att_n0) v(xcase81.att_n1) v(xcase81.att_n2) v(xcase81.att_p0) v(xcase81.att_p1) v(xcase81.att_p2) v(cctrl81) v(cm81) v(xcase81.inn) v(xcase81.inp) v(inx81) v(iny81) v(xcase81.nbias) v(outn81) v(outp81) v(xcase81.p_bias) v(rctrl81) v(xcase81.s1) v(xcase81.s2) v(vdd81)
ac dec 50 1meg 100g
wrdata ac_022.txt v(outp0) v(outn0) v(vid0) v(outp81) v(outn81) v(vid81)
alter Vr0 1.188
alter Vc0 0.054
op
wrdata op_023.txt i(vsupply0) v(xcase0.att_n0) v(xcase0.att_n1) v(xcase0.att_n2) v(xcase0.att_p0) v(xcase0.att_p1) v(xcase0.att_p2) v(cctrl0) v(cm0) v(xcase0.inn) v(xcase0.inp) v(inx0) v(iny0) v(xcase0.nbias) v(outn0) v(outp0) v(xcase0.p_bias) v(xcase0.rc_ct) v(xcase0.rc_gate) v(xcase0.rc_mid) v(rctrl0) v(xcase0.s1) v(xcase0.s2) v(vdd0) i(vsupply81) v(xcase81.att_n0) v(xcase81.att_n1) v(xcase81.att_n2) v(xcase81.att_p0) v(xcase81.att_p1) v(xcase81.att_p2) v(cctrl81) v(cm81) v(xcase81.inn) v(xcase81.inp) v(inx81) v(iny81) v(xcase81.nbias) v(outn81) v(outp81) v(xcase81.p_bias) v(rctrl81) v(xcase81.s1) v(xcase81.s2) v(vdd81)
ac dec 50 1meg 100g
wrdata ac_023.txt v(outp0) v(outn0) v(vid0) v(outp81) v(outn81) v(vid81)
alter Vr0 1.188
alter Vc0 0.081
op
wrdata op_024.txt i(vsupply0) v(xcase0.att_n0) v(xcase0.att_n1) v(xcase0.att_n2) v(xcase0.att_p0) v(xcase0.att_p1) v(xcase0.att_p2) v(cctrl0) v(cm0) v(xcase0.inn) v(xcase0.inp) v(inx0) v(iny0) v(xcase0.nbias) v(outn0) v(outp0) v(xcase0.p_bias) v(xcase0.rc_ct) v(xcase0.rc_gate) v(xcase0.rc_mid) v(rctrl0) v(xcase0.s1) v(xcase0.s2) v(vdd0) i(vsupply81) v(xcase81.att_n0) v(xcase81.att_n1) v(xcase81.att_n2) v(xcase81.att_p0) v(xcase81.att_p1) v(xcase81.att_p2) v(cctrl81) v(cm81) v(xcase81.inn) v(xcase81.inp) v(inx81) v(iny81) v(xcase81.nbias) v(outn81) v(outp81) v(xcase81.p_bias) v(rctrl81) v(xcase81.s1) v(xcase81.s2) v(vdd81)
ac dec 50 1meg 100g
wrdata ac_024.txt v(outp0) v(outn0) v(vid0) v(outp81) v(outn81) v(vid81)
alter Vr0 1.188
alter Vc0 0.108
op
wrdata op_025.txt i(vsupply0) v(xcase0.att_n0) v(xcase0.att_n1) v(xcase0.att_n2) v(xcase0.att_p0) v(xcase0.att_p1) v(xcase0.att_p2) v(cctrl0) v(cm0) v(xcase0.inn) v(xcase0.inp) v(inx0) v(iny0) v(xcase0.nbias) v(outn0) v(outp0) v(xcase0.p_bias) v(xcase0.rc_ct) v(xcase0.rc_gate) v(xcase0.rc_mid) v(rctrl0) v(xcase0.s1) v(xcase0.s2) v(vdd0) i(vsupply81) v(xcase81.att_n0) v(xcase81.att_n1) v(xcase81.att_n2) v(xcase81.att_p0) v(xcase81.att_p1) v(xcase81.att_p2) v(cctrl81) v(cm81) v(xcase81.inn) v(xcase81.inp) v(inx81) v(iny81) v(xcase81.nbias) v(outn81) v(outp81) v(xcase81.p_bias) v(rctrl81) v(xcase81.s1) v(xcase81.s2) v(vdd81)
ac dec 50 1meg 100g
wrdata ac_025.txt v(outp0) v(outn0) v(vid0) v(outp81) v(outn81) v(vid81)
alter Vr0 1.188
alter Vc0 0.135
op
wrdata op_026.txt i(vsupply0) v(xcase0.att_n0) v(xcase0.att_n1) v(xcase0.att_n2) v(xcase0.att_p0) v(xcase0.att_p1) v(xcase0.att_p2) v(cctrl0) v(cm0) v(xcase0.inn) v(xcase0.inp) v(inx0) v(iny0) v(xcase0.nbias) v(outn0) v(outp0) v(xcase0.p_bias) v(xcase0.rc_ct) v(xcase0.rc_gate) v(xcase0.rc_mid) v(rctrl0) v(xcase0.s1) v(xcase0.s2) v(vdd0) i(vsupply81) v(xcase81.att_n0) v(xcase81.att_n1) v(xcase81.att_n2) v(xcase81.att_p0) v(xcase81.att_p1) v(xcase81.att_p2) v(cctrl81) v(cm81) v(xcase81.inn) v(xcase81.inp) v(inx81) v(iny81) v(xcase81.nbias) v(outn81) v(outp81) v(xcase81.p_bias) v(rctrl81) v(xcase81.s1) v(xcase81.s2) v(vdd81)
ac dec 50 1meg 100g
wrdata ac_026.txt v(outp0) v(outn0) v(vid0) v(outp81) v(outn81) v(vid81)
alter Vr0 1.188
alter Vc0 0.162
op
wrdata op_027.txt i(vsupply0) v(xcase0.att_n0) v(xcase0.att_n1) v(xcase0.att_n2) v(xcase0.att_p0) v(xcase0.att_p1) v(xcase0.att_p2) v(cctrl0) v(cm0) v(xcase0.inn) v(xcase0.inp) v(inx0) v(iny0) v(xcase0.nbias) v(outn0) v(outp0) v(xcase0.p_bias) v(xcase0.rc_ct) v(xcase0.rc_gate) v(xcase0.rc_mid) v(rctrl0) v(xcase0.s1) v(xcase0.s2) v(vdd0) i(vsupply81) v(xcase81.att_n0) v(xcase81.att_n1) v(xcase81.att_n2) v(xcase81.att_p0) v(xcase81.att_p1) v(xcase81.att_p2) v(cctrl81) v(cm81) v(xcase81.inn) v(xcase81.inp) v(inx81) v(iny81) v(xcase81.nbias) v(outn81) v(outp81) v(xcase81.p_bias) v(rctrl81) v(xcase81.s1) v(xcase81.s2) v(vdd81)
ac dec 50 1meg 100g
wrdata ac_027.txt v(outp0) v(outn0) v(vid0) v(outp81) v(outn81) v(vid81)
alter Vr0 1.188
alter Vc0 0.189
op
wrdata op_028.txt i(vsupply0) v(xcase0.att_n0) v(xcase0.att_n1) v(xcase0.att_n2) v(xcase0.att_p0) v(xcase0.att_p1) v(xcase0.att_p2) v(cctrl0) v(cm0) v(xcase0.inn) v(xcase0.inp) v(inx0) v(iny0) v(xcase0.nbias) v(outn0) v(outp0) v(xcase0.p_bias) v(xcase0.rc_ct) v(xcase0.rc_gate) v(xcase0.rc_mid) v(rctrl0) v(xcase0.s1) v(xcase0.s2) v(vdd0) i(vsupply81) v(xcase81.att_n0) v(xcase81.att_n1) v(xcase81.att_n2) v(xcase81.att_p0) v(xcase81.att_p1) v(xcase81.att_p2) v(cctrl81) v(cm81) v(xcase81.inn) v(xcase81.inp) v(inx81) v(iny81) v(xcase81.nbias) v(outn81) v(outp81) v(xcase81.p_bias) v(rctrl81) v(xcase81.s1) v(xcase81.s2) v(vdd81)
ac dec 50 1meg 100g
wrdata ac_028.txt v(outp0) v(outn0) v(vid0) v(outp81) v(outn81) v(vid81)
alter Vr0 1.188
alter Vc0 0.216
op
wrdata op_029.txt i(vsupply0) v(xcase0.att_n0) v(xcase0.att_n1) v(xcase0.att_n2) v(xcase0.att_p0) v(xcase0.att_p1) v(xcase0.att_p2) v(cctrl0) v(cm0) v(xcase0.inn) v(xcase0.inp) v(inx0) v(iny0) v(xcase0.nbias) v(outn0) v(outp0) v(xcase0.p_bias) v(xcase0.rc_ct) v(xcase0.rc_gate) v(xcase0.rc_mid) v(rctrl0) v(xcase0.s1) v(xcase0.s2) v(vdd0) i(vsupply81) v(xcase81.att_n0) v(xcase81.att_n1) v(xcase81.att_n2) v(xcase81.att_p0) v(xcase81.att_p1) v(xcase81.att_p2) v(cctrl81) v(cm81) v(xcase81.inn) v(xcase81.inp) v(inx81) v(iny81) v(xcase81.nbias) v(outn81) v(outp81) v(xcase81.p_bias) v(rctrl81) v(xcase81.s1) v(xcase81.s2) v(vdd81)
ac dec 50 1meg 100g
wrdata ac_029.txt v(outp0) v(outn0) v(vid0) v(outp81) v(outn81) v(vid81)
alter Vr0 1.188
alter Vc0 0.243
op
wrdata op_030.txt i(vsupply0) v(xcase0.att_n0) v(xcase0.att_n1) v(xcase0.att_n2) v(xcase0.att_p0) v(xcase0.att_p1) v(xcase0.att_p2) v(cctrl0) v(cm0) v(xcase0.inn) v(xcase0.inp) v(inx0) v(iny0) v(xcase0.nbias) v(outn0) v(outp0) v(xcase0.p_bias) v(xcase0.rc_ct) v(xcase0.rc_gate) v(xcase0.rc_mid) v(rctrl0) v(xcase0.s1) v(xcase0.s2) v(vdd0) i(vsupply81) v(xcase81.att_n0) v(xcase81.att_n1) v(xcase81.att_n2) v(xcase81.att_p0) v(xcase81.att_p1) v(xcase81.att_p2) v(cctrl81) v(cm81) v(xcase81.inn) v(xcase81.inp) v(inx81) v(iny81) v(xcase81.nbias) v(outn81) v(outp81) v(xcase81.p_bias) v(rctrl81) v(xcase81.s1) v(xcase81.s2) v(vdd81)
ac dec 50 1meg 100g
wrdata ac_030.txt v(outp0) v(outn0) v(vid0) v(outp81) v(outn81) v(vid81)
alter Vr0 1.188
alter Vc0 0.27
op
wrdata op_031.txt i(vsupply0) v(xcase0.att_n0) v(xcase0.att_n1) v(xcase0.att_n2) v(xcase0.att_p0) v(xcase0.att_p1) v(xcase0.att_p2) v(cctrl0) v(cm0) v(xcase0.inn) v(xcase0.inp) v(inx0) v(iny0) v(xcase0.nbias) v(outn0) v(outp0) v(xcase0.p_bias) v(xcase0.rc_ct) v(xcase0.rc_gate) v(xcase0.rc_mid) v(rctrl0) v(xcase0.s1) v(xcase0.s2) v(vdd0) i(vsupply81) v(xcase81.att_n0) v(xcase81.att_n1) v(xcase81.att_n2) v(xcase81.att_p0) v(xcase81.att_p1) v(xcase81.att_p2) v(cctrl81) v(cm81) v(xcase81.inn) v(xcase81.inp) v(inx81) v(iny81) v(xcase81.nbias) v(outn81) v(outp81) v(xcase81.p_bias) v(rctrl81) v(xcase81.s1) v(xcase81.s2) v(vdd81)
ac dec 50 1meg 100g
wrdata ac_031.txt v(outp0) v(outn0) v(vid0) v(outp81) v(outn81) v(vid81)
alter Vr0 1.188
alter Vc0 0.297
op
wrdata op_032.txt i(vsupply0) v(xcase0.att_n0) v(xcase0.att_n1) v(xcase0.att_n2) v(xcase0.att_p0) v(xcase0.att_p1) v(xcase0.att_p2) v(cctrl0) v(cm0) v(xcase0.inn) v(xcase0.inp) v(inx0) v(iny0) v(xcase0.nbias) v(outn0) v(outp0) v(xcase0.p_bias) v(xcase0.rc_ct) v(xcase0.rc_gate) v(xcase0.rc_mid) v(rctrl0) v(xcase0.s1) v(xcase0.s2) v(vdd0) i(vsupply81) v(xcase81.att_n0) v(xcase81.att_n1) v(xcase81.att_n2) v(xcase81.att_p0) v(xcase81.att_p1) v(xcase81.att_p2) v(cctrl81) v(cm81) v(xcase81.inn) v(xcase81.inp) v(inx81) v(iny81) v(xcase81.nbias) v(outn81) v(outp81) v(xcase81.p_bias) v(rctrl81) v(xcase81.s1) v(xcase81.s2) v(vdd81)
ac dec 50 1meg 100g
wrdata ac_032.txt v(outp0) v(outn0) v(vid0) v(outp81) v(outn81) v(vid81)
alter Vr0 1.188
alter Vc0 0.324
op
wrdata op_033.txt i(vsupply0) v(xcase0.att_n0) v(xcase0.att_n1) v(xcase0.att_n2) v(xcase0.att_p0) v(xcase0.att_p1) v(xcase0.att_p2) v(cctrl0) v(cm0) v(xcase0.inn) v(xcase0.inp) v(inx0) v(iny0) v(xcase0.nbias) v(outn0) v(outp0) v(xcase0.p_bias) v(xcase0.rc_ct) v(xcase0.rc_gate) v(xcase0.rc_mid) v(rctrl0) v(xcase0.s1) v(xcase0.s2) v(vdd0) i(vsupply81) v(xcase81.att_n0) v(xcase81.att_n1) v(xcase81.att_n2) v(xcase81.att_p0) v(xcase81.att_p1) v(xcase81.att_p2) v(cctrl81) v(cm81) v(xcase81.inn) v(xcase81.inp) v(inx81) v(iny81) v(xcase81.nbias) v(outn81) v(outp81) v(xcase81.p_bias) v(rctrl81) v(xcase81.s1) v(xcase81.s2) v(vdd81)
ac dec 50 1meg 100g
wrdata ac_033.txt v(outp0) v(outn0) v(vid0) v(outp81) v(outn81) v(vid81)
alter Vr0 1.188
alter Vc0 0.351
op
wrdata op_034.txt i(vsupply0) v(xcase0.att_n0) v(xcase0.att_n1) v(xcase0.att_n2) v(xcase0.att_p0) v(xcase0.att_p1) v(xcase0.att_p2) v(cctrl0) v(cm0) v(xcase0.inn) v(xcase0.inp) v(inx0) v(iny0) v(xcase0.nbias) v(outn0) v(outp0) v(xcase0.p_bias) v(xcase0.rc_ct) v(xcase0.rc_gate) v(xcase0.rc_mid) v(rctrl0) v(xcase0.s1) v(xcase0.s2) v(vdd0) i(vsupply81) v(xcase81.att_n0) v(xcase81.att_n1) v(xcase81.att_n2) v(xcase81.att_p0) v(xcase81.att_p1) v(xcase81.att_p2) v(cctrl81) v(cm81) v(xcase81.inn) v(xcase81.inp) v(inx81) v(iny81) v(xcase81.nbias) v(outn81) v(outp81) v(xcase81.p_bias) v(rctrl81) v(xcase81.s1) v(xcase81.s2) v(vdd81)
ac dec 50 1meg 100g
wrdata ac_034.txt v(outp0) v(outn0) v(vid0) v(outp81) v(outn81) v(vid81)
alter Vr0 1.188
alter Vc0 0.378
op
wrdata op_035.txt i(vsupply0) v(xcase0.att_n0) v(xcase0.att_n1) v(xcase0.att_n2) v(xcase0.att_p0) v(xcase0.att_p1) v(xcase0.att_p2) v(cctrl0) v(cm0) v(xcase0.inn) v(xcase0.inp) v(inx0) v(iny0) v(xcase0.nbias) v(outn0) v(outp0) v(xcase0.p_bias) v(xcase0.rc_ct) v(xcase0.rc_gate) v(xcase0.rc_mid) v(rctrl0) v(xcase0.s1) v(xcase0.s2) v(vdd0) i(vsupply81) v(xcase81.att_n0) v(xcase81.att_n1) v(xcase81.att_n2) v(xcase81.att_p0) v(xcase81.att_p1) v(xcase81.att_p2) v(cctrl81) v(cm81) v(xcase81.inn) v(xcase81.inp) v(inx81) v(iny81) v(xcase81.nbias) v(outn81) v(outp81) v(xcase81.p_bias) v(rctrl81) v(xcase81.s1) v(xcase81.s2) v(vdd81)
ac dec 50 1meg 100g
wrdata ac_035.txt v(outp0) v(outn0) v(vid0) v(outp81) v(outn81) v(vid81)
alter Vr0 1.188
alter Vc0 0.405
op
wrdata op_036.txt i(vsupply0) v(xcase0.att_n0) v(xcase0.att_n1) v(xcase0.att_n2) v(xcase0.att_p0) v(xcase0.att_p1) v(xcase0.att_p2) v(cctrl0) v(cm0) v(xcase0.inn) v(xcase0.inp) v(inx0) v(iny0) v(xcase0.nbias) v(outn0) v(outp0) v(xcase0.p_bias) v(xcase0.rc_ct) v(xcase0.rc_gate) v(xcase0.rc_mid) v(rctrl0) v(xcase0.s1) v(xcase0.s2) v(vdd0) i(vsupply81) v(xcase81.att_n0) v(xcase81.att_n1) v(xcase81.att_n2) v(xcase81.att_p0) v(xcase81.att_p1) v(xcase81.att_p2) v(cctrl81) v(cm81) v(xcase81.inn) v(xcase81.inp) v(inx81) v(iny81) v(xcase81.nbias) v(outn81) v(outp81) v(xcase81.p_bias) v(rctrl81) v(xcase81.s1) v(xcase81.s2) v(vdd81)
ac dec 50 1meg 100g
wrdata ac_036.txt v(outp0) v(outn0) v(vid0) v(outp81) v(outn81) v(vid81)
alter Vr0 1.188
alter Vc0 0.432
op
wrdata op_037.txt i(vsupply0) v(xcase0.att_n0) v(xcase0.att_n1) v(xcase0.att_n2) v(xcase0.att_p0) v(xcase0.att_p1) v(xcase0.att_p2) v(cctrl0) v(cm0) v(xcase0.inn) v(xcase0.inp) v(inx0) v(iny0) v(xcase0.nbias) v(outn0) v(outp0) v(xcase0.p_bias) v(xcase0.rc_ct) v(xcase0.rc_gate) v(xcase0.rc_mid) v(rctrl0) v(xcase0.s1) v(xcase0.s2) v(vdd0) i(vsupply81) v(xcase81.att_n0) v(xcase81.att_n1) v(xcase81.att_n2) v(xcase81.att_p0) v(xcase81.att_p1) v(xcase81.att_p2) v(cctrl81) v(cm81) v(xcase81.inn) v(xcase81.inp) v(inx81) v(iny81) v(xcase81.nbias) v(outn81) v(outp81) v(xcase81.p_bias) v(rctrl81) v(xcase81.s1) v(xcase81.s2) v(vdd81)
ac dec 50 1meg 100g
wrdata ac_037.txt v(outp0) v(outn0) v(vid0) v(outp81) v(outn81) v(vid81)
alter Vr0 1.188
alter Vc0 0.459
op
wrdata op_038.txt i(vsupply0) v(xcase0.att_n0) v(xcase0.att_n1) v(xcase0.att_n2) v(xcase0.att_p0) v(xcase0.att_p1) v(xcase0.att_p2) v(cctrl0) v(cm0) v(xcase0.inn) v(xcase0.inp) v(inx0) v(iny0) v(xcase0.nbias) v(outn0) v(outp0) v(xcase0.p_bias) v(xcase0.rc_ct) v(xcase0.rc_gate) v(xcase0.rc_mid) v(rctrl0) v(xcase0.s1) v(xcase0.s2) v(vdd0) i(vsupply81) v(xcase81.att_n0) v(xcase81.att_n1) v(xcase81.att_n2) v(xcase81.att_p0) v(xcase81.att_p1) v(xcase81.att_p2) v(cctrl81) v(cm81) v(xcase81.inn) v(xcase81.inp) v(inx81) v(iny81) v(xcase81.nbias) v(outn81) v(outp81) v(xcase81.p_bias) v(rctrl81) v(xcase81.s1) v(xcase81.s2) v(vdd81)
ac dec 50 1meg 100g
wrdata ac_038.txt v(outp0) v(outn0) v(vid0) v(outp81) v(outn81) v(vid81)
alter Vr0 1.188
alter Vc0 0.486
op
wrdata op_039.txt i(vsupply0) v(xcase0.att_n0) v(xcase0.att_n1) v(xcase0.att_n2) v(xcase0.att_p0) v(xcase0.att_p1) v(xcase0.att_p2) v(cctrl0) v(cm0) v(xcase0.inn) v(xcase0.inp) v(inx0) v(iny0) v(xcase0.nbias) v(outn0) v(outp0) v(xcase0.p_bias) v(xcase0.rc_ct) v(xcase0.rc_gate) v(xcase0.rc_mid) v(rctrl0) v(xcase0.s1) v(xcase0.s2) v(vdd0) i(vsupply81) v(xcase81.att_n0) v(xcase81.att_n1) v(xcase81.att_n2) v(xcase81.att_p0) v(xcase81.att_p1) v(xcase81.att_p2) v(cctrl81) v(cm81) v(xcase81.inn) v(xcase81.inp) v(inx81) v(iny81) v(xcase81.nbias) v(outn81) v(outp81) v(xcase81.p_bias) v(rctrl81) v(xcase81.s1) v(xcase81.s2) v(vdd81)
ac dec 50 1meg 100g
wrdata ac_039.txt v(outp0) v(outn0) v(vid0) v(outp81) v(outn81) v(vid81)
alter Vr0 1.188
alter Vc0 0.513
op
wrdata op_040.txt i(vsupply0) v(xcase0.att_n0) v(xcase0.att_n1) v(xcase0.att_n2) v(xcase0.att_p0) v(xcase0.att_p1) v(xcase0.att_p2) v(cctrl0) v(cm0) v(xcase0.inn) v(xcase0.inp) v(inx0) v(iny0) v(xcase0.nbias) v(outn0) v(outp0) v(xcase0.p_bias) v(xcase0.rc_ct) v(xcase0.rc_gate) v(xcase0.rc_mid) v(rctrl0) v(xcase0.s1) v(xcase0.s2) v(vdd0) i(vsupply81) v(xcase81.att_n0) v(xcase81.att_n1) v(xcase81.att_n2) v(xcase81.att_p0) v(xcase81.att_p1) v(xcase81.att_p2) v(cctrl81) v(cm81) v(xcase81.inn) v(xcase81.inp) v(inx81) v(iny81) v(xcase81.nbias) v(outn81) v(outp81) v(xcase81.p_bias) v(rctrl81) v(xcase81.s1) v(xcase81.s2) v(vdd81)
ac dec 50 1meg 100g
wrdata ac_040.txt v(outp0) v(outn0) v(vid0) v(outp81) v(outn81) v(vid81)
alter Vr0 1.188
alter Vc0 0.54
op
wrdata op_041.txt i(vsupply0) v(xcase0.att_n0) v(xcase0.att_n1) v(xcase0.att_n2) v(xcase0.att_p0) v(xcase0.att_p1) v(xcase0.att_p2) v(cctrl0) v(cm0) v(xcase0.inn) v(xcase0.inp) v(inx0) v(iny0) v(xcase0.nbias) v(outn0) v(outp0) v(xcase0.p_bias) v(xcase0.rc_ct) v(xcase0.rc_gate) v(xcase0.rc_mid) v(rctrl0) v(xcase0.s1) v(xcase0.s2) v(vdd0) i(vsupply81) v(xcase81.att_n0) v(xcase81.att_n1) v(xcase81.att_n2) v(xcase81.att_p0) v(xcase81.att_p1) v(xcase81.att_p2) v(cctrl81) v(cm81) v(xcase81.inn) v(xcase81.inp) v(inx81) v(iny81) v(xcase81.nbias) v(outn81) v(outp81) v(xcase81.p_bias) v(rctrl81) v(xcase81.s1) v(xcase81.s2) v(vdd81)
ac dec 50 1meg 100g
wrdata ac_041.txt v(outp0) v(outn0) v(vid0) v(outp81) v(outn81) v(vid81)
alter Vr0 1.206
alter Vc0 0
op
wrdata op_042.txt i(vsupply0) v(xcase0.att_n0) v(xcase0.att_n1) v(xcase0.att_n2) v(xcase0.att_p0) v(xcase0.att_p1) v(xcase0.att_p2) v(cctrl0) v(cm0) v(xcase0.inn) v(xcase0.inp) v(inx0) v(iny0) v(xcase0.nbias) v(outn0) v(outp0) v(xcase0.p_bias) v(xcase0.rc_ct) v(xcase0.rc_gate) v(xcase0.rc_mid) v(rctrl0) v(xcase0.s1) v(xcase0.s2) v(vdd0) i(vsupply81) v(xcase81.att_n0) v(xcase81.att_n1) v(xcase81.att_n2) v(xcase81.att_p0) v(xcase81.att_p1) v(xcase81.att_p2) v(cctrl81) v(cm81) v(xcase81.inn) v(xcase81.inp) v(inx81) v(iny81) v(xcase81.nbias) v(outn81) v(outp81) v(xcase81.p_bias) v(rctrl81) v(xcase81.s1) v(xcase81.s2) v(vdd81)
ac dec 50 1meg 100g
wrdata ac_042.txt v(outp0) v(outn0) v(vid0) v(outp81) v(outn81) v(vid81)
alter Vr0 1.206
alter Vc0 0.027
op
wrdata op_043.txt i(vsupply0) v(xcase0.att_n0) v(xcase0.att_n1) v(xcase0.att_n2) v(xcase0.att_p0) v(xcase0.att_p1) v(xcase0.att_p2) v(cctrl0) v(cm0) v(xcase0.inn) v(xcase0.inp) v(inx0) v(iny0) v(xcase0.nbias) v(outn0) v(outp0) v(xcase0.p_bias) v(xcase0.rc_ct) v(xcase0.rc_gate) v(xcase0.rc_mid) v(rctrl0) v(xcase0.s1) v(xcase0.s2) v(vdd0) i(vsupply81) v(xcase81.att_n0) v(xcase81.att_n1) v(xcase81.att_n2) v(xcase81.att_p0) v(xcase81.att_p1) v(xcase81.att_p2) v(cctrl81) v(cm81) v(xcase81.inn) v(xcase81.inp) v(inx81) v(iny81) v(xcase81.nbias) v(outn81) v(outp81) v(xcase81.p_bias) v(rctrl81) v(xcase81.s1) v(xcase81.s2) v(vdd81)
ac dec 50 1meg 100g
wrdata ac_043.txt v(outp0) v(outn0) v(vid0) v(outp81) v(outn81) v(vid81)
alter Vr0 1.206
alter Vc0 0.054
op
wrdata op_044.txt i(vsupply0) v(xcase0.att_n0) v(xcase0.att_n1) v(xcase0.att_n2) v(xcase0.att_p0) v(xcase0.att_p1) v(xcase0.att_p2) v(cctrl0) v(cm0) v(xcase0.inn) v(xcase0.inp) v(inx0) v(iny0) v(xcase0.nbias) v(outn0) v(outp0) v(xcase0.p_bias) v(xcase0.rc_ct) v(xcase0.rc_gate) v(xcase0.rc_mid) v(rctrl0) v(xcase0.s1) v(xcase0.s2) v(vdd0) i(vsupply81) v(xcase81.att_n0) v(xcase81.att_n1) v(xcase81.att_n2) v(xcase81.att_p0) v(xcase81.att_p1) v(xcase81.att_p2) v(cctrl81) v(cm81) v(xcase81.inn) v(xcase81.inp) v(inx81) v(iny81) v(xcase81.nbias) v(outn81) v(outp81) v(xcase81.p_bias) v(rctrl81) v(xcase81.s1) v(xcase81.s2) v(vdd81)
ac dec 50 1meg 100g
wrdata ac_044.txt v(outp0) v(outn0) v(vid0) v(outp81) v(outn81) v(vid81)
alter Vr0 1.206
alter Vc0 0.081
op
wrdata op_045.txt i(vsupply0) v(xcase0.att_n0) v(xcase0.att_n1) v(xcase0.att_n2) v(xcase0.att_p0) v(xcase0.att_p1) v(xcase0.att_p2) v(cctrl0) v(cm0) v(xcase0.inn) v(xcase0.inp) v(inx0) v(iny0) v(xcase0.nbias) v(outn0) v(outp0) v(xcase0.p_bias) v(xcase0.rc_ct) v(xcase0.rc_gate) v(xcase0.rc_mid) v(rctrl0) v(xcase0.s1) v(xcase0.s2) v(vdd0) i(vsupply81) v(xcase81.att_n0) v(xcase81.att_n1) v(xcase81.att_n2) v(xcase81.att_p0) v(xcase81.att_p1) v(xcase81.att_p2) v(cctrl81) v(cm81) v(xcase81.inn) v(xcase81.inp) v(inx81) v(iny81) v(xcase81.nbias) v(outn81) v(outp81) v(xcase81.p_bias) v(rctrl81) v(xcase81.s1) v(xcase81.s2) v(vdd81)
ac dec 50 1meg 100g
wrdata ac_045.txt v(outp0) v(outn0) v(vid0) v(outp81) v(outn81) v(vid81)
alter Vr0 1.206
alter Vc0 0.108
op
wrdata op_046.txt i(vsupply0) v(xcase0.att_n0) v(xcase0.att_n1) v(xcase0.att_n2) v(xcase0.att_p0) v(xcase0.att_p1) v(xcase0.att_p2) v(cctrl0) v(cm0) v(xcase0.inn) v(xcase0.inp) v(inx0) v(iny0) v(xcase0.nbias) v(outn0) v(outp0) v(xcase0.p_bias) v(xcase0.rc_ct) v(xcase0.rc_gate) v(xcase0.rc_mid) v(rctrl0) v(xcase0.s1) v(xcase0.s2) v(vdd0) i(vsupply81) v(xcase81.att_n0) v(xcase81.att_n1) v(xcase81.att_n2) v(xcase81.att_p0) v(xcase81.att_p1) v(xcase81.att_p2) v(cctrl81) v(cm81) v(xcase81.inn) v(xcase81.inp) v(inx81) v(iny81) v(xcase81.nbias) v(outn81) v(outp81) v(xcase81.p_bias) v(rctrl81) v(xcase81.s1) v(xcase81.s2) v(vdd81)
ac dec 50 1meg 100g
wrdata ac_046.txt v(outp0) v(outn0) v(vid0) v(outp81) v(outn81) v(vid81)
alter Vr0 1.206
alter Vc0 0.135
op
wrdata op_047.txt i(vsupply0) v(xcase0.att_n0) v(xcase0.att_n1) v(xcase0.att_n2) v(xcase0.att_p0) v(xcase0.att_p1) v(xcase0.att_p2) v(cctrl0) v(cm0) v(xcase0.inn) v(xcase0.inp) v(inx0) v(iny0) v(xcase0.nbias) v(outn0) v(outp0) v(xcase0.p_bias) v(xcase0.rc_ct) v(xcase0.rc_gate) v(xcase0.rc_mid) v(rctrl0) v(xcase0.s1) v(xcase0.s2) v(vdd0) i(vsupply81) v(xcase81.att_n0) v(xcase81.att_n1) v(xcase81.att_n2) v(xcase81.att_p0) v(xcase81.att_p1) v(xcase81.att_p2) v(cctrl81) v(cm81) v(xcase81.inn) v(xcase81.inp) v(inx81) v(iny81) v(xcase81.nbias) v(outn81) v(outp81) v(xcase81.p_bias) v(rctrl81) v(xcase81.s1) v(xcase81.s2) v(vdd81)
ac dec 50 1meg 100g
wrdata ac_047.txt v(outp0) v(outn0) v(vid0) v(outp81) v(outn81) v(vid81)
alter Vr0 1.206
alter Vc0 0.162
op
wrdata op_048.txt i(vsupply0) v(xcase0.att_n0) v(xcase0.att_n1) v(xcase0.att_n2) v(xcase0.att_p0) v(xcase0.att_p1) v(xcase0.att_p2) v(cctrl0) v(cm0) v(xcase0.inn) v(xcase0.inp) v(inx0) v(iny0) v(xcase0.nbias) v(outn0) v(outp0) v(xcase0.p_bias) v(xcase0.rc_ct) v(xcase0.rc_gate) v(xcase0.rc_mid) v(rctrl0) v(xcase0.s1) v(xcase0.s2) v(vdd0) i(vsupply81) v(xcase81.att_n0) v(xcase81.att_n1) v(xcase81.att_n2) v(xcase81.att_p0) v(xcase81.att_p1) v(xcase81.att_p2) v(cctrl81) v(cm81) v(xcase81.inn) v(xcase81.inp) v(inx81) v(iny81) v(xcase81.nbias) v(outn81) v(outp81) v(xcase81.p_bias) v(rctrl81) v(xcase81.s1) v(xcase81.s2) v(vdd81)
ac dec 50 1meg 100g
wrdata ac_048.txt v(outp0) v(outn0) v(vid0) v(outp81) v(outn81) v(vid81)
alter Vr0 1.206
alter Vc0 0.189
op
wrdata op_049.txt i(vsupply0) v(xcase0.att_n0) v(xcase0.att_n1) v(xcase0.att_n2) v(xcase0.att_p0) v(xcase0.att_p1) v(xcase0.att_p2) v(cctrl0) v(cm0) v(xcase0.inn) v(xcase0.inp) v(inx0) v(iny0) v(xcase0.nbias) v(outn0) v(outp0) v(xcase0.p_bias) v(xcase0.rc_ct) v(xcase0.rc_gate) v(xcase0.rc_mid) v(rctrl0) v(xcase0.s1) v(xcase0.s2) v(vdd0) i(vsupply81) v(xcase81.att_n0) v(xcase81.att_n1) v(xcase81.att_n2) v(xcase81.att_p0) v(xcase81.att_p1) v(xcase81.att_p2) v(cctrl81) v(cm81) v(xcase81.inn) v(xcase81.inp) v(inx81) v(iny81) v(xcase81.nbias) v(outn81) v(outp81) v(xcase81.p_bias) v(rctrl81) v(xcase81.s1) v(xcase81.s2) v(vdd81)
ac dec 50 1meg 100g
wrdata ac_049.txt v(outp0) v(outn0) v(vid0) v(outp81) v(outn81) v(vid81)
alter Vr0 1.206
alter Vc0 0.216
op
wrdata op_050.txt i(vsupply0) v(xcase0.att_n0) v(xcase0.att_n1) v(xcase0.att_n2) v(xcase0.att_p0) v(xcase0.att_p1) v(xcase0.att_p2) v(cctrl0) v(cm0) v(xcase0.inn) v(xcase0.inp) v(inx0) v(iny0) v(xcase0.nbias) v(outn0) v(outp0) v(xcase0.p_bias) v(xcase0.rc_ct) v(xcase0.rc_gate) v(xcase0.rc_mid) v(rctrl0) v(xcase0.s1) v(xcase0.s2) v(vdd0) i(vsupply81) v(xcase81.att_n0) v(xcase81.att_n1) v(xcase81.att_n2) v(xcase81.att_p0) v(xcase81.att_p1) v(xcase81.att_p2) v(cctrl81) v(cm81) v(xcase81.inn) v(xcase81.inp) v(inx81) v(iny81) v(xcase81.nbias) v(outn81) v(outp81) v(xcase81.p_bias) v(rctrl81) v(xcase81.s1) v(xcase81.s2) v(vdd81)
ac dec 50 1meg 100g
wrdata ac_050.txt v(outp0) v(outn0) v(vid0) v(outp81) v(outn81) v(vid81)
alter Vr0 1.206
alter Vc0 0.243
op
wrdata op_051.txt i(vsupply0) v(xcase0.att_n0) v(xcase0.att_n1) v(xcase0.att_n2) v(xcase0.att_p0) v(xcase0.att_p1) v(xcase0.att_p2) v(cctrl0) v(cm0) v(xcase0.inn) v(xcase0.inp) v(inx0) v(iny0) v(xcase0.nbias) v(outn0) v(outp0) v(xcase0.p_bias) v(xcase0.rc_ct) v(xcase0.rc_gate) v(xcase0.rc_mid) v(rctrl0) v(xcase0.s1) v(xcase0.s2) v(vdd0) i(vsupply81) v(xcase81.att_n0) v(xcase81.att_n1) v(xcase81.att_n2) v(xcase81.att_p0) v(xcase81.att_p1) v(xcase81.att_p2) v(cctrl81) v(cm81) v(xcase81.inn) v(xcase81.inp) v(inx81) v(iny81) v(xcase81.nbias) v(outn81) v(outp81) v(xcase81.p_bias) v(rctrl81) v(xcase81.s1) v(xcase81.s2) v(vdd81)
ac dec 50 1meg 100g
wrdata ac_051.txt v(outp0) v(outn0) v(vid0) v(outp81) v(outn81) v(vid81)
alter Vr0 1.206
alter Vc0 0.27
op
wrdata op_052.txt i(vsupply0) v(xcase0.att_n0) v(xcase0.att_n1) v(xcase0.att_n2) v(xcase0.att_p0) v(xcase0.att_p1) v(xcase0.att_p2) v(cctrl0) v(cm0) v(xcase0.inn) v(xcase0.inp) v(inx0) v(iny0) v(xcase0.nbias) v(outn0) v(outp0) v(xcase0.p_bias) v(xcase0.rc_ct) v(xcase0.rc_gate) v(xcase0.rc_mid) v(rctrl0) v(xcase0.s1) v(xcase0.s2) v(vdd0) i(vsupply81) v(xcase81.att_n0) v(xcase81.att_n1) v(xcase81.att_n2) v(xcase81.att_p0) v(xcase81.att_p1) v(xcase81.att_p2) v(cctrl81) v(cm81) v(xcase81.inn) v(xcase81.inp) v(inx81) v(iny81) v(xcase81.nbias) v(outn81) v(outp81) v(xcase81.p_bias) v(rctrl81) v(xcase81.s1) v(xcase81.s2) v(vdd81)
ac dec 50 1meg 100g
wrdata ac_052.txt v(outp0) v(outn0) v(vid0) v(outp81) v(outn81) v(vid81)
alter Vr0 1.206
alter Vc0 0.297
op
wrdata op_053.txt i(vsupply0) v(xcase0.att_n0) v(xcase0.att_n1) v(xcase0.att_n2) v(xcase0.att_p0) v(xcase0.att_p1) v(xcase0.att_p2) v(cctrl0) v(cm0) v(xcase0.inn) v(xcase0.inp) v(inx0) v(iny0) v(xcase0.nbias) v(outn0) v(outp0) v(xcase0.p_bias) v(xcase0.rc_ct) v(xcase0.rc_gate) v(xcase0.rc_mid) v(rctrl0) v(xcase0.s1) v(xcase0.s2) v(vdd0) i(vsupply81) v(xcase81.att_n0) v(xcase81.att_n1) v(xcase81.att_n2) v(xcase81.att_p0) v(xcase81.att_p1) v(xcase81.att_p2) v(cctrl81) v(cm81) v(xcase81.inn) v(xcase81.inp) v(inx81) v(iny81) v(xcase81.nbias) v(outn81) v(outp81) v(xcase81.p_bias) v(rctrl81) v(xcase81.s1) v(xcase81.s2) v(vdd81)
ac dec 50 1meg 100g
wrdata ac_053.txt v(outp0) v(outn0) v(vid0) v(outp81) v(outn81) v(vid81)
alter Vr0 1.206
alter Vc0 0.324
op
wrdata op_054.txt i(vsupply0) v(xcase0.att_n0) v(xcase0.att_n1) v(xcase0.att_n2) v(xcase0.att_p0) v(xcase0.att_p1) v(xcase0.att_p2) v(cctrl0) v(cm0) v(xcase0.inn) v(xcase0.inp) v(inx0) v(iny0) v(xcase0.nbias) v(outn0) v(outp0) v(xcase0.p_bias) v(xcase0.rc_ct) v(xcase0.rc_gate) v(xcase0.rc_mid) v(rctrl0) v(xcase0.s1) v(xcase0.s2) v(vdd0) i(vsupply81) v(xcase81.att_n0) v(xcase81.att_n1) v(xcase81.att_n2) v(xcase81.att_p0) v(xcase81.att_p1) v(xcase81.att_p2) v(cctrl81) v(cm81) v(xcase81.inn) v(xcase81.inp) v(inx81) v(iny81) v(xcase81.nbias) v(outn81) v(outp81) v(xcase81.p_bias) v(rctrl81) v(xcase81.s1) v(xcase81.s2) v(vdd81)
ac dec 50 1meg 100g
wrdata ac_054.txt v(outp0) v(outn0) v(vid0) v(outp81) v(outn81) v(vid81)
alter Vr0 1.206
alter Vc0 0.351
op
wrdata op_055.txt i(vsupply0) v(xcase0.att_n0) v(xcase0.att_n1) v(xcase0.att_n2) v(xcase0.att_p0) v(xcase0.att_p1) v(xcase0.att_p2) v(cctrl0) v(cm0) v(xcase0.inn) v(xcase0.inp) v(inx0) v(iny0) v(xcase0.nbias) v(outn0) v(outp0) v(xcase0.p_bias) v(xcase0.rc_ct) v(xcase0.rc_gate) v(xcase0.rc_mid) v(rctrl0) v(xcase0.s1) v(xcase0.s2) v(vdd0) i(vsupply81) v(xcase81.att_n0) v(xcase81.att_n1) v(xcase81.att_n2) v(xcase81.att_p0) v(xcase81.att_p1) v(xcase81.att_p2) v(cctrl81) v(cm81) v(xcase81.inn) v(xcase81.inp) v(inx81) v(iny81) v(xcase81.nbias) v(outn81) v(outp81) v(xcase81.p_bias) v(rctrl81) v(xcase81.s1) v(xcase81.s2) v(vdd81)
ac dec 50 1meg 100g
wrdata ac_055.txt v(outp0) v(outn0) v(vid0) v(outp81) v(outn81) v(vid81)
alter Vr0 1.206
alter Vc0 0.378
op
wrdata op_056.txt i(vsupply0) v(xcase0.att_n0) v(xcase0.att_n1) v(xcase0.att_n2) v(xcase0.att_p0) v(xcase0.att_p1) v(xcase0.att_p2) v(cctrl0) v(cm0) v(xcase0.inn) v(xcase0.inp) v(inx0) v(iny0) v(xcase0.nbias) v(outn0) v(outp0) v(xcase0.p_bias) v(xcase0.rc_ct) v(xcase0.rc_gate) v(xcase0.rc_mid) v(rctrl0) v(xcase0.s1) v(xcase0.s2) v(vdd0) i(vsupply81) v(xcase81.att_n0) v(xcase81.att_n1) v(xcase81.att_n2) v(xcase81.att_p0) v(xcase81.att_p1) v(xcase81.att_p2) v(cctrl81) v(cm81) v(xcase81.inn) v(xcase81.inp) v(inx81) v(iny81) v(xcase81.nbias) v(outn81) v(outp81) v(xcase81.p_bias) v(rctrl81) v(xcase81.s1) v(xcase81.s2) v(vdd81)
ac dec 50 1meg 100g
wrdata ac_056.txt v(outp0) v(outn0) v(vid0) v(outp81) v(outn81) v(vid81)
alter Vr0 1.206
alter Vc0 0.405
op
wrdata op_057.txt i(vsupply0) v(xcase0.att_n0) v(xcase0.att_n1) v(xcase0.att_n2) v(xcase0.att_p0) v(xcase0.att_p1) v(xcase0.att_p2) v(cctrl0) v(cm0) v(xcase0.inn) v(xcase0.inp) v(inx0) v(iny0) v(xcase0.nbias) v(outn0) v(outp0) v(xcase0.p_bias) v(xcase0.rc_ct) v(xcase0.rc_gate) v(xcase0.rc_mid) v(rctrl0) v(xcase0.s1) v(xcase0.s2) v(vdd0) i(vsupply81) v(xcase81.att_n0) v(xcase81.att_n1) v(xcase81.att_n2) v(xcase81.att_p0) v(xcase81.att_p1) v(xcase81.att_p2) v(cctrl81) v(cm81) v(xcase81.inn) v(xcase81.inp) v(inx81) v(iny81) v(xcase81.nbias) v(outn81) v(outp81) v(xcase81.p_bias) v(rctrl81) v(xcase81.s1) v(xcase81.s2) v(vdd81)
ac dec 50 1meg 100g
wrdata ac_057.txt v(outp0) v(outn0) v(vid0) v(outp81) v(outn81) v(vid81)
alter Vr0 1.206
alter Vc0 0.432
op
wrdata op_058.txt i(vsupply0) v(xcase0.att_n0) v(xcase0.att_n1) v(xcase0.att_n2) v(xcase0.att_p0) v(xcase0.att_p1) v(xcase0.att_p2) v(cctrl0) v(cm0) v(xcase0.inn) v(xcase0.inp) v(inx0) v(iny0) v(xcase0.nbias) v(outn0) v(outp0) v(xcase0.p_bias) v(xcase0.rc_ct) v(xcase0.rc_gate) v(xcase0.rc_mid) v(rctrl0) v(xcase0.s1) v(xcase0.s2) v(vdd0) i(vsupply81) v(xcase81.att_n0) v(xcase81.att_n1) v(xcase81.att_n2) v(xcase81.att_p0) v(xcase81.att_p1) v(xcase81.att_p2) v(cctrl81) v(cm81) v(xcase81.inn) v(xcase81.inp) v(inx81) v(iny81) v(xcase81.nbias) v(outn81) v(outp81) v(xcase81.p_bias) v(rctrl81) v(xcase81.s1) v(xcase81.s2) v(vdd81)
ac dec 50 1meg 100g
wrdata ac_058.txt v(outp0) v(outn0) v(vid0) v(outp81) v(outn81) v(vid81)
alter Vr0 1.206
alter Vc0 0.459
op
wrdata op_059.txt i(vsupply0) v(xcase0.att_n0) v(xcase0.att_n1) v(xcase0.att_n2) v(xcase0.att_p0) v(xcase0.att_p1) v(xcase0.att_p2) v(cctrl0) v(cm0) v(xcase0.inn) v(xcase0.inp) v(inx0) v(iny0) v(xcase0.nbias) v(outn0) v(outp0) v(xcase0.p_bias) v(xcase0.rc_ct) v(xcase0.rc_gate) v(xcase0.rc_mid) v(rctrl0) v(xcase0.s1) v(xcase0.s2) v(vdd0) i(vsupply81) v(xcase81.att_n0) v(xcase81.att_n1) v(xcase81.att_n2) v(xcase81.att_p0) v(xcase81.att_p1) v(xcase81.att_p2) v(cctrl81) v(cm81) v(xcase81.inn) v(xcase81.inp) v(inx81) v(iny81) v(xcase81.nbias) v(outn81) v(outp81) v(xcase81.p_bias) v(rctrl81) v(xcase81.s1) v(xcase81.s2) v(vdd81)
ac dec 50 1meg 100g
wrdata ac_059.txt v(outp0) v(outn0) v(vid0) v(outp81) v(outn81) v(vid81)
alter Vr0 1.206
alter Vc0 0.486
op
wrdata op_060.txt i(vsupply0) v(xcase0.att_n0) v(xcase0.att_n1) v(xcase0.att_n2) v(xcase0.att_p0) v(xcase0.att_p1) v(xcase0.att_p2) v(cctrl0) v(cm0) v(xcase0.inn) v(xcase0.inp) v(inx0) v(iny0) v(xcase0.nbias) v(outn0) v(outp0) v(xcase0.p_bias) v(xcase0.rc_ct) v(xcase0.rc_gate) v(xcase0.rc_mid) v(rctrl0) v(xcase0.s1) v(xcase0.s2) v(vdd0) i(vsupply81) v(xcase81.att_n0) v(xcase81.att_n1) v(xcase81.att_n2) v(xcase81.att_p0) v(xcase81.att_p1) v(xcase81.att_p2) v(cctrl81) v(cm81) v(xcase81.inn) v(xcase81.inp) v(inx81) v(iny81) v(xcase81.nbias) v(outn81) v(outp81) v(xcase81.p_bias) v(rctrl81) v(xcase81.s1) v(xcase81.s2) v(vdd81)
ac dec 50 1meg 100g
wrdata ac_060.txt v(outp0) v(outn0) v(vid0) v(outp81) v(outn81) v(vid81)
alter Vr0 1.206
alter Vc0 0.513
op
wrdata op_061.txt i(vsupply0) v(xcase0.att_n0) v(xcase0.att_n1) v(xcase0.att_n2) v(xcase0.att_p0) v(xcase0.att_p1) v(xcase0.att_p2) v(cctrl0) v(cm0) v(xcase0.inn) v(xcase0.inp) v(inx0) v(iny0) v(xcase0.nbias) v(outn0) v(outp0) v(xcase0.p_bias) v(xcase0.rc_ct) v(xcase0.rc_gate) v(xcase0.rc_mid) v(rctrl0) v(xcase0.s1) v(xcase0.s2) v(vdd0) i(vsupply81) v(xcase81.att_n0) v(xcase81.att_n1) v(xcase81.att_n2) v(xcase81.att_p0) v(xcase81.att_p1) v(xcase81.att_p2) v(cctrl81) v(cm81) v(xcase81.inn) v(xcase81.inp) v(inx81) v(iny81) v(xcase81.nbias) v(outn81) v(outp81) v(xcase81.p_bias) v(rctrl81) v(xcase81.s1) v(xcase81.s2) v(vdd81)
ac dec 50 1meg 100g
wrdata ac_061.txt v(outp0) v(outn0) v(vid0) v(outp81) v(outn81) v(vid81)
alter Vr0 1.206
alter Vc0 0.54
op
wrdata op_062.txt i(vsupply0) v(xcase0.att_n0) v(xcase0.att_n1) v(xcase0.att_n2) v(xcase0.att_p0) v(xcase0.att_p1) v(xcase0.att_p2) v(cctrl0) v(cm0) v(xcase0.inn) v(xcase0.inp) v(inx0) v(iny0) v(xcase0.nbias) v(outn0) v(outp0) v(xcase0.p_bias) v(xcase0.rc_ct) v(xcase0.rc_gate) v(xcase0.rc_mid) v(rctrl0) v(xcase0.s1) v(xcase0.s2) v(vdd0) i(vsupply81) v(xcase81.att_n0) v(xcase81.att_n1) v(xcase81.att_n2) v(xcase81.att_p0) v(xcase81.att_p1) v(xcase81.att_p2) v(cctrl81) v(cm81) v(xcase81.inn) v(xcase81.inp) v(inx81) v(iny81) v(xcase81.nbias) v(outn81) v(outp81) v(xcase81.p_bias) v(rctrl81) v(xcase81.s1) v(xcase81.s2) v(vdd81)
ac dec 50 1meg 100g
wrdata ac_062.txt v(outp0) v(outn0) v(vid0) v(outp81) v(outn81) v(vid81)
alter Vr0 1.224
alter Vc0 0
op
wrdata op_063.txt i(vsupply0) v(xcase0.att_n0) v(xcase0.att_n1) v(xcase0.att_n2) v(xcase0.att_p0) v(xcase0.att_p1) v(xcase0.att_p2) v(cctrl0) v(cm0) v(xcase0.inn) v(xcase0.inp) v(inx0) v(iny0) v(xcase0.nbias) v(outn0) v(outp0) v(xcase0.p_bias) v(xcase0.rc_ct) v(xcase0.rc_gate) v(xcase0.rc_mid) v(rctrl0) v(xcase0.s1) v(xcase0.s2) v(vdd0) i(vsupply81) v(xcase81.att_n0) v(xcase81.att_n1) v(xcase81.att_n2) v(xcase81.att_p0) v(xcase81.att_p1) v(xcase81.att_p2) v(cctrl81) v(cm81) v(xcase81.inn) v(xcase81.inp) v(inx81) v(iny81) v(xcase81.nbias) v(outn81) v(outp81) v(xcase81.p_bias) v(rctrl81) v(xcase81.s1) v(xcase81.s2) v(vdd81)
ac dec 50 1meg 100g
wrdata ac_063.txt v(outp0) v(outn0) v(vid0) v(outp81) v(outn81) v(vid81)
alter Vr0 1.224
alter Vc0 0.027
op
wrdata op_064.txt i(vsupply0) v(xcase0.att_n0) v(xcase0.att_n1) v(xcase0.att_n2) v(xcase0.att_p0) v(xcase0.att_p1) v(xcase0.att_p2) v(cctrl0) v(cm0) v(xcase0.inn) v(xcase0.inp) v(inx0) v(iny0) v(xcase0.nbias) v(outn0) v(outp0) v(xcase0.p_bias) v(xcase0.rc_ct) v(xcase0.rc_gate) v(xcase0.rc_mid) v(rctrl0) v(xcase0.s1) v(xcase0.s2) v(vdd0) i(vsupply81) v(xcase81.att_n0) v(xcase81.att_n1) v(xcase81.att_n2) v(xcase81.att_p0) v(xcase81.att_p1) v(xcase81.att_p2) v(cctrl81) v(cm81) v(xcase81.inn) v(xcase81.inp) v(inx81) v(iny81) v(xcase81.nbias) v(outn81) v(outp81) v(xcase81.p_bias) v(rctrl81) v(xcase81.s1) v(xcase81.s2) v(vdd81)
ac dec 50 1meg 100g
wrdata ac_064.txt v(outp0) v(outn0) v(vid0) v(outp81) v(outn81) v(vid81)
alter Vr0 1.224
alter Vc0 0.054
op
wrdata op_065.txt i(vsupply0) v(xcase0.att_n0) v(xcase0.att_n1) v(xcase0.att_n2) v(xcase0.att_p0) v(xcase0.att_p1) v(xcase0.att_p2) v(cctrl0) v(cm0) v(xcase0.inn) v(xcase0.inp) v(inx0) v(iny0) v(xcase0.nbias) v(outn0) v(outp0) v(xcase0.p_bias) v(xcase0.rc_ct) v(xcase0.rc_gate) v(xcase0.rc_mid) v(rctrl0) v(xcase0.s1) v(xcase0.s2) v(vdd0) i(vsupply81) v(xcase81.att_n0) v(xcase81.att_n1) v(xcase81.att_n2) v(xcase81.att_p0) v(xcase81.att_p1) v(xcase81.att_p2) v(cctrl81) v(cm81) v(xcase81.inn) v(xcase81.inp) v(inx81) v(iny81) v(xcase81.nbias) v(outn81) v(outp81) v(xcase81.p_bias) v(rctrl81) v(xcase81.s1) v(xcase81.s2) v(vdd81)
ac dec 50 1meg 100g
wrdata ac_065.txt v(outp0) v(outn0) v(vid0) v(outp81) v(outn81) v(vid81)
alter Vr0 1.224
alter Vc0 0.081
op
wrdata op_066.txt i(vsupply0) v(xcase0.att_n0) v(xcase0.att_n1) v(xcase0.att_n2) v(xcase0.att_p0) v(xcase0.att_p1) v(xcase0.att_p2) v(cctrl0) v(cm0) v(xcase0.inn) v(xcase0.inp) v(inx0) v(iny0) v(xcase0.nbias) v(outn0) v(outp0) v(xcase0.p_bias) v(xcase0.rc_ct) v(xcase0.rc_gate) v(xcase0.rc_mid) v(rctrl0) v(xcase0.s1) v(xcase0.s2) v(vdd0) i(vsupply81) v(xcase81.att_n0) v(xcase81.att_n1) v(xcase81.att_n2) v(xcase81.att_p0) v(xcase81.att_p1) v(xcase81.att_p2) v(cctrl81) v(cm81) v(xcase81.inn) v(xcase81.inp) v(inx81) v(iny81) v(xcase81.nbias) v(outn81) v(outp81) v(xcase81.p_bias) v(rctrl81) v(xcase81.s1) v(xcase81.s2) v(vdd81)
ac dec 50 1meg 100g
wrdata ac_066.txt v(outp0) v(outn0) v(vid0) v(outp81) v(outn81) v(vid81)
alter Vr0 1.224
alter Vc0 0.108
op
wrdata op_067.txt i(vsupply0) v(xcase0.att_n0) v(xcase0.att_n1) v(xcase0.att_n2) v(xcase0.att_p0) v(xcase0.att_p1) v(xcase0.att_p2) v(cctrl0) v(cm0) v(xcase0.inn) v(xcase0.inp) v(inx0) v(iny0) v(xcase0.nbias) v(outn0) v(outp0) v(xcase0.p_bias) v(xcase0.rc_ct) v(xcase0.rc_gate) v(xcase0.rc_mid) v(rctrl0) v(xcase0.s1) v(xcase0.s2) v(vdd0) i(vsupply81) v(xcase81.att_n0) v(xcase81.att_n1) v(xcase81.att_n2) v(xcase81.att_p0) v(xcase81.att_p1) v(xcase81.att_p2) v(cctrl81) v(cm81) v(xcase81.inn) v(xcase81.inp) v(inx81) v(iny81) v(xcase81.nbias) v(outn81) v(outp81) v(xcase81.p_bias) v(rctrl81) v(xcase81.s1) v(xcase81.s2) v(vdd81)
ac dec 50 1meg 100g
wrdata ac_067.txt v(outp0) v(outn0) v(vid0) v(outp81) v(outn81) v(vid81)
alter Vr0 1.224
alter Vc0 0.135
op
wrdata op_068.txt i(vsupply0) v(xcase0.att_n0) v(xcase0.att_n1) v(xcase0.att_n2) v(xcase0.att_p0) v(xcase0.att_p1) v(xcase0.att_p2) v(cctrl0) v(cm0) v(xcase0.inn) v(xcase0.inp) v(inx0) v(iny0) v(xcase0.nbias) v(outn0) v(outp0) v(xcase0.p_bias) v(xcase0.rc_ct) v(xcase0.rc_gate) v(xcase0.rc_mid) v(rctrl0) v(xcase0.s1) v(xcase0.s2) v(vdd0) i(vsupply81) v(xcase81.att_n0) v(xcase81.att_n1) v(xcase81.att_n2) v(xcase81.att_p0) v(xcase81.att_p1) v(xcase81.att_p2) v(cctrl81) v(cm81) v(xcase81.inn) v(xcase81.inp) v(inx81) v(iny81) v(xcase81.nbias) v(outn81) v(outp81) v(xcase81.p_bias) v(rctrl81) v(xcase81.s1) v(xcase81.s2) v(vdd81)
ac dec 50 1meg 100g
wrdata ac_068.txt v(outp0) v(outn0) v(vid0) v(outp81) v(outn81) v(vid81)
alter Vr0 1.224
alter Vc0 0.162
op
wrdata op_069.txt i(vsupply0) v(xcase0.att_n0) v(xcase0.att_n1) v(xcase0.att_n2) v(xcase0.att_p0) v(xcase0.att_p1) v(xcase0.att_p2) v(cctrl0) v(cm0) v(xcase0.inn) v(xcase0.inp) v(inx0) v(iny0) v(xcase0.nbias) v(outn0) v(outp0) v(xcase0.p_bias) v(xcase0.rc_ct) v(xcase0.rc_gate) v(xcase0.rc_mid) v(rctrl0) v(xcase0.s1) v(xcase0.s2) v(vdd0) i(vsupply81) v(xcase81.att_n0) v(xcase81.att_n1) v(xcase81.att_n2) v(xcase81.att_p0) v(xcase81.att_p1) v(xcase81.att_p2) v(cctrl81) v(cm81) v(xcase81.inn) v(xcase81.inp) v(inx81) v(iny81) v(xcase81.nbias) v(outn81) v(outp81) v(xcase81.p_bias) v(rctrl81) v(xcase81.s1) v(xcase81.s2) v(vdd81)
ac dec 50 1meg 100g
wrdata ac_069.txt v(outp0) v(outn0) v(vid0) v(outp81) v(outn81) v(vid81)
alter Vr0 1.224
alter Vc0 0.189
op
wrdata op_070.txt i(vsupply0) v(xcase0.att_n0) v(xcase0.att_n1) v(xcase0.att_n2) v(xcase0.att_p0) v(xcase0.att_p1) v(xcase0.att_p2) v(cctrl0) v(cm0) v(xcase0.inn) v(xcase0.inp) v(inx0) v(iny0) v(xcase0.nbias) v(outn0) v(outp0) v(xcase0.p_bias) v(xcase0.rc_ct) v(xcase0.rc_gate) v(xcase0.rc_mid) v(rctrl0) v(xcase0.s1) v(xcase0.s2) v(vdd0) i(vsupply81) v(xcase81.att_n0) v(xcase81.att_n1) v(xcase81.att_n2) v(xcase81.att_p0) v(xcase81.att_p1) v(xcase81.att_p2) v(cctrl81) v(cm81) v(xcase81.inn) v(xcase81.inp) v(inx81) v(iny81) v(xcase81.nbias) v(outn81) v(outp81) v(xcase81.p_bias) v(rctrl81) v(xcase81.s1) v(xcase81.s2) v(vdd81)
ac dec 50 1meg 100g
wrdata ac_070.txt v(outp0) v(outn0) v(vid0) v(outp81) v(outn81) v(vid81)
alter Vr0 1.224
alter Vc0 0.216
op
wrdata op_071.txt i(vsupply0) v(xcase0.att_n0) v(xcase0.att_n1) v(xcase0.att_n2) v(xcase0.att_p0) v(xcase0.att_p1) v(xcase0.att_p2) v(cctrl0) v(cm0) v(xcase0.inn) v(xcase0.inp) v(inx0) v(iny0) v(xcase0.nbias) v(outn0) v(outp0) v(xcase0.p_bias) v(xcase0.rc_ct) v(xcase0.rc_gate) v(xcase0.rc_mid) v(rctrl0) v(xcase0.s1) v(xcase0.s2) v(vdd0) i(vsupply81) v(xcase81.att_n0) v(xcase81.att_n1) v(xcase81.att_n2) v(xcase81.att_p0) v(xcase81.att_p1) v(xcase81.att_p2) v(cctrl81) v(cm81) v(xcase81.inn) v(xcase81.inp) v(inx81) v(iny81) v(xcase81.nbias) v(outn81) v(outp81) v(xcase81.p_bias) v(rctrl81) v(xcase81.s1) v(xcase81.s2) v(vdd81)
ac dec 50 1meg 100g
wrdata ac_071.txt v(outp0) v(outn0) v(vid0) v(outp81) v(outn81) v(vid81)
alter Vr0 1.224
alter Vc0 0.243
op
wrdata op_072.txt i(vsupply0) v(xcase0.att_n0) v(xcase0.att_n1) v(xcase0.att_n2) v(xcase0.att_p0) v(xcase0.att_p1) v(xcase0.att_p2) v(cctrl0) v(cm0) v(xcase0.inn) v(xcase0.inp) v(inx0) v(iny0) v(xcase0.nbias) v(outn0) v(outp0) v(xcase0.p_bias) v(xcase0.rc_ct) v(xcase0.rc_gate) v(xcase0.rc_mid) v(rctrl0) v(xcase0.s1) v(xcase0.s2) v(vdd0) i(vsupply81) v(xcase81.att_n0) v(xcase81.att_n1) v(xcase81.att_n2) v(xcase81.att_p0) v(xcase81.att_p1) v(xcase81.att_p2) v(cctrl81) v(cm81) v(xcase81.inn) v(xcase81.inp) v(inx81) v(iny81) v(xcase81.nbias) v(outn81) v(outp81) v(xcase81.p_bias) v(rctrl81) v(xcase81.s1) v(xcase81.s2) v(vdd81)
ac dec 50 1meg 100g
wrdata ac_072.txt v(outp0) v(outn0) v(vid0) v(outp81) v(outn81) v(vid81)
alter Vr0 1.224
alter Vc0 0.27
op
wrdata op_073.txt i(vsupply0) v(xcase0.att_n0) v(xcase0.att_n1) v(xcase0.att_n2) v(xcase0.att_p0) v(xcase0.att_p1) v(xcase0.att_p2) v(cctrl0) v(cm0) v(xcase0.inn) v(xcase0.inp) v(inx0) v(iny0) v(xcase0.nbias) v(outn0) v(outp0) v(xcase0.p_bias) v(xcase0.rc_ct) v(xcase0.rc_gate) v(xcase0.rc_mid) v(rctrl0) v(xcase0.s1) v(xcase0.s2) v(vdd0) i(vsupply81) v(xcase81.att_n0) v(xcase81.att_n1) v(xcase81.att_n2) v(xcase81.att_p0) v(xcase81.att_p1) v(xcase81.att_p2) v(cctrl81) v(cm81) v(xcase81.inn) v(xcase81.inp) v(inx81) v(iny81) v(xcase81.nbias) v(outn81) v(outp81) v(xcase81.p_bias) v(rctrl81) v(xcase81.s1) v(xcase81.s2) v(vdd81)
ac dec 50 1meg 100g
wrdata ac_073.txt v(outp0) v(outn0) v(vid0) v(outp81) v(outn81) v(vid81)
alter Vr0 1.224
alter Vc0 0.297
op
wrdata op_074.txt i(vsupply0) v(xcase0.att_n0) v(xcase0.att_n1) v(xcase0.att_n2) v(xcase0.att_p0) v(xcase0.att_p1) v(xcase0.att_p2) v(cctrl0) v(cm0) v(xcase0.inn) v(xcase0.inp) v(inx0) v(iny0) v(xcase0.nbias) v(outn0) v(outp0) v(xcase0.p_bias) v(xcase0.rc_ct) v(xcase0.rc_gate) v(xcase0.rc_mid) v(rctrl0) v(xcase0.s1) v(xcase0.s2) v(vdd0) i(vsupply81) v(xcase81.att_n0) v(xcase81.att_n1) v(xcase81.att_n2) v(xcase81.att_p0) v(xcase81.att_p1) v(xcase81.att_p2) v(cctrl81) v(cm81) v(xcase81.inn) v(xcase81.inp) v(inx81) v(iny81) v(xcase81.nbias) v(outn81) v(outp81) v(xcase81.p_bias) v(rctrl81) v(xcase81.s1) v(xcase81.s2) v(vdd81)
ac dec 50 1meg 100g
wrdata ac_074.txt v(outp0) v(outn0) v(vid0) v(outp81) v(outn81) v(vid81)
alter Vr0 1.224
alter Vc0 0.324
op
wrdata op_075.txt i(vsupply0) v(xcase0.att_n0) v(xcase0.att_n1) v(xcase0.att_n2) v(xcase0.att_p0) v(xcase0.att_p1) v(xcase0.att_p2) v(cctrl0) v(cm0) v(xcase0.inn) v(xcase0.inp) v(inx0) v(iny0) v(xcase0.nbias) v(outn0) v(outp0) v(xcase0.p_bias) v(xcase0.rc_ct) v(xcase0.rc_gate) v(xcase0.rc_mid) v(rctrl0) v(xcase0.s1) v(xcase0.s2) v(vdd0) i(vsupply81) v(xcase81.att_n0) v(xcase81.att_n1) v(xcase81.att_n2) v(xcase81.att_p0) v(xcase81.att_p1) v(xcase81.att_p2) v(cctrl81) v(cm81) v(xcase81.inn) v(xcase81.inp) v(inx81) v(iny81) v(xcase81.nbias) v(outn81) v(outp81) v(xcase81.p_bias) v(rctrl81) v(xcase81.s1) v(xcase81.s2) v(vdd81)
ac dec 50 1meg 100g
wrdata ac_075.txt v(outp0) v(outn0) v(vid0) v(outp81) v(outn81) v(vid81)
alter Vr0 1.224
alter Vc0 0.351
op
wrdata op_076.txt i(vsupply0) v(xcase0.att_n0) v(xcase0.att_n1) v(xcase0.att_n2) v(xcase0.att_p0) v(xcase0.att_p1) v(xcase0.att_p2) v(cctrl0) v(cm0) v(xcase0.inn) v(xcase0.inp) v(inx0) v(iny0) v(xcase0.nbias) v(outn0) v(outp0) v(xcase0.p_bias) v(xcase0.rc_ct) v(xcase0.rc_gate) v(xcase0.rc_mid) v(rctrl0) v(xcase0.s1) v(xcase0.s2) v(vdd0) i(vsupply81) v(xcase81.att_n0) v(xcase81.att_n1) v(xcase81.att_n2) v(xcase81.att_p0) v(xcase81.att_p1) v(xcase81.att_p2) v(cctrl81) v(cm81) v(xcase81.inn) v(xcase81.inp) v(inx81) v(iny81) v(xcase81.nbias) v(outn81) v(outp81) v(xcase81.p_bias) v(rctrl81) v(xcase81.s1) v(xcase81.s2) v(vdd81)
ac dec 50 1meg 100g
wrdata ac_076.txt v(outp0) v(outn0) v(vid0) v(outp81) v(outn81) v(vid81)
alter Vr0 1.224
alter Vc0 0.378
op
wrdata op_077.txt i(vsupply0) v(xcase0.att_n0) v(xcase0.att_n1) v(xcase0.att_n2) v(xcase0.att_p0) v(xcase0.att_p1) v(xcase0.att_p2) v(cctrl0) v(cm0) v(xcase0.inn) v(xcase0.inp) v(inx0) v(iny0) v(xcase0.nbias) v(outn0) v(outp0) v(xcase0.p_bias) v(xcase0.rc_ct) v(xcase0.rc_gate) v(xcase0.rc_mid) v(rctrl0) v(xcase0.s1) v(xcase0.s2) v(vdd0) i(vsupply81) v(xcase81.att_n0) v(xcase81.att_n1) v(xcase81.att_n2) v(xcase81.att_p0) v(xcase81.att_p1) v(xcase81.att_p2) v(cctrl81) v(cm81) v(xcase81.inn) v(xcase81.inp) v(inx81) v(iny81) v(xcase81.nbias) v(outn81) v(outp81) v(xcase81.p_bias) v(rctrl81) v(xcase81.s1) v(xcase81.s2) v(vdd81)
ac dec 50 1meg 100g
wrdata ac_077.txt v(outp0) v(outn0) v(vid0) v(outp81) v(outn81) v(vid81)
alter Vr0 1.224
alter Vc0 0.405
op
wrdata op_078.txt i(vsupply0) v(xcase0.att_n0) v(xcase0.att_n1) v(xcase0.att_n2) v(xcase0.att_p0) v(xcase0.att_p1) v(xcase0.att_p2) v(cctrl0) v(cm0) v(xcase0.inn) v(xcase0.inp) v(inx0) v(iny0) v(xcase0.nbias) v(outn0) v(outp0) v(xcase0.p_bias) v(xcase0.rc_ct) v(xcase0.rc_gate) v(xcase0.rc_mid) v(rctrl0) v(xcase0.s1) v(xcase0.s2) v(vdd0) i(vsupply81) v(xcase81.att_n0) v(xcase81.att_n1) v(xcase81.att_n2) v(xcase81.att_p0) v(xcase81.att_p1) v(xcase81.att_p2) v(cctrl81) v(cm81) v(xcase81.inn) v(xcase81.inp) v(inx81) v(iny81) v(xcase81.nbias) v(outn81) v(outp81) v(xcase81.p_bias) v(rctrl81) v(xcase81.s1) v(xcase81.s2) v(vdd81)
ac dec 50 1meg 100g
wrdata ac_078.txt v(outp0) v(outn0) v(vid0) v(outp81) v(outn81) v(vid81)
alter Vr0 1.224
alter Vc0 0.432
op
wrdata op_079.txt i(vsupply0) v(xcase0.att_n0) v(xcase0.att_n1) v(xcase0.att_n2) v(xcase0.att_p0) v(xcase0.att_p1) v(xcase0.att_p2) v(cctrl0) v(cm0) v(xcase0.inn) v(xcase0.inp) v(inx0) v(iny0) v(xcase0.nbias) v(outn0) v(outp0) v(xcase0.p_bias) v(xcase0.rc_ct) v(xcase0.rc_gate) v(xcase0.rc_mid) v(rctrl0) v(xcase0.s1) v(xcase0.s2) v(vdd0) i(vsupply81) v(xcase81.att_n0) v(xcase81.att_n1) v(xcase81.att_n2) v(xcase81.att_p0) v(xcase81.att_p1) v(xcase81.att_p2) v(cctrl81) v(cm81) v(xcase81.inn) v(xcase81.inp) v(inx81) v(iny81) v(xcase81.nbias) v(outn81) v(outp81) v(xcase81.p_bias) v(rctrl81) v(xcase81.s1) v(xcase81.s2) v(vdd81)
ac dec 50 1meg 100g
wrdata ac_079.txt v(outp0) v(outn0) v(vid0) v(outp81) v(outn81) v(vid81)
alter Vr0 1.224
alter Vc0 0.459
op
wrdata op_080.txt i(vsupply0) v(xcase0.att_n0) v(xcase0.att_n1) v(xcase0.att_n2) v(xcase0.att_p0) v(xcase0.att_p1) v(xcase0.att_p2) v(cctrl0) v(cm0) v(xcase0.inn) v(xcase0.inp) v(inx0) v(iny0) v(xcase0.nbias) v(outn0) v(outp0) v(xcase0.p_bias) v(xcase0.rc_ct) v(xcase0.rc_gate) v(xcase0.rc_mid) v(rctrl0) v(xcase0.s1) v(xcase0.s2) v(vdd0) i(vsupply81) v(xcase81.att_n0) v(xcase81.att_n1) v(xcase81.att_n2) v(xcase81.att_p0) v(xcase81.att_p1) v(xcase81.att_p2) v(cctrl81) v(cm81) v(xcase81.inn) v(xcase81.inp) v(inx81) v(iny81) v(xcase81.nbias) v(outn81) v(outp81) v(xcase81.p_bias) v(rctrl81) v(xcase81.s1) v(xcase81.s2) v(vdd81)
ac dec 50 1meg 100g
wrdata ac_080.txt v(outp0) v(outn0) v(vid0) v(outp81) v(outn81) v(vid81)
alter Vr0 1.224
alter Vc0 0.486
op
wrdata op_081.txt i(vsupply0) v(xcase0.att_n0) v(xcase0.att_n1) v(xcase0.att_n2) v(xcase0.att_p0) v(xcase0.att_p1) v(xcase0.att_p2) v(cctrl0) v(cm0) v(xcase0.inn) v(xcase0.inp) v(inx0) v(iny0) v(xcase0.nbias) v(outn0) v(outp0) v(xcase0.p_bias) v(xcase0.rc_ct) v(xcase0.rc_gate) v(xcase0.rc_mid) v(rctrl0) v(xcase0.s1) v(xcase0.s2) v(vdd0) i(vsupply81) v(xcase81.att_n0) v(xcase81.att_n1) v(xcase81.att_n2) v(xcase81.att_p0) v(xcase81.att_p1) v(xcase81.att_p2) v(cctrl81) v(cm81) v(xcase81.inn) v(xcase81.inp) v(inx81) v(iny81) v(xcase81.nbias) v(outn81) v(outp81) v(xcase81.p_bias) v(rctrl81) v(xcase81.s1) v(xcase81.s2) v(vdd81)
ac dec 50 1meg 100g
wrdata ac_081.txt v(outp0) v(outn0) v(vid0) v(outp81) v(outn81) v(vid81)
alter Vr0 1.224
alter Vc0 0.513
op
wrdata op_082.txt i(vsupply0) v(xcase0.att_n0) v(xcase0.att_n1) v(xcase0.att_n2) v(xcase0.att_p0) v(xcase0.att_p1) v(xcase0.att_p2) v(cctrl0) v(cm0) v(xcase0.inn) v(xcase0.inp) v(inx0) v(iny0) v(xcase0.nbias) v(outn0) v(outp0) v(xcase0.p_bias) v(xcase0.rc_ct) v(xcase0.rc_gate) v(xcase0.rc_mid) v(rctrl0) v(xcase0.s1) v(xcase0.s2) v(vdd0) i(vsupply81) v(xcase81.att_n0) v(xcase81.att_n1) v(xcase81.att_n2) v(xcase81.att_p0) v(xcase81.att_p1) v(xcase81.att_p2) v(cctrl81) v(cm81) v(xcase81.inn) v(xcase81.inp) v(inx81) v(iny81) v(xcase81.nbias) v(outn81) v(outp81) v(xcase81.p_bias) v(rctrl81) v(xcase81.s1) v(xcase81.s2) v(vdd81)
ac dec 50 1meg 100g
wrdata ac_082.txt v(outp0) v(outn0) v(vid0) v(outp81) v(outn81) v(vid81)
alter Vr0 1.224
alter Vc0 0.54
op
wrdata op_083.txt i(vsupply0) v(xcase0.att_n0) v(xcase0.att_n1) v(xcase0.att_n2) v(xcase0.att_p0) v(xcase0.att_p1) v(xcase0.att_p2) v(cctrl0) v(cm0) v(xcase0.inn) v(xcase0.inp) v(inx0) v(iny0) v(xcase0.nbias) v(outn0) v(outp0) v(xcase0.p_bias) v(xcase0.rc_ct) v(xcase0.rc_gate) v(xcase0.rc_mid) v(rctrl0) v(xcase0.s1) v(xcase0.s2) v(vdd0) i(vsupply81) v(xcase81.att_n0) v(xcase81.att_n1) v(xcase81.att_n2) v(xcase81.att_p0) v(xcase81.att_p1) v(xcase81.att_p2) v(cctrl81) v(cm81) v(xcase81.inn) v(xcase81.inp) v(inx81) v(iny81) v(xcase81.nbias) v(outn81) v(outp81) v(xcase81.p_bias) v(rctrl81) v(xcase81.s1) v(xcase81.s2) v(vdd81)
ac dec 50 1meg 100g
wrdata ac_083.txt v(outp0) v(outn0) v(vid0) v(outp81) v(outn81) v(vid81)
alter Vr0 1.242
alter Vc0 0
op
wrdata op_084.txt i(vsupply0) v(xcase0.att_n0) v(xcase0.att_n1) v(xcase0.att_n2) v(xcase0.att_p0) v(xcase0.att_p1) v(xcase0.att_p2) v(cctrl0) v(cm0) v(xcase0.inn) v(xcase0.inp) v(inx0) v(iny0) v(xcase0.nbias) v(outn0) v(outp0) v(xcase0.p_bias) v(xcase0.rc_ct) v(xcase0.rc_gate) v(xcase0.rc_mid) v(rctrl0) v(xcase0.s1) v(xcase0.s2) v(vdd0) i(vsupply81) v(xcase81.att_n0) v(xcase81.att_n1) v(xcase81.att_n2) v(xcase81.att_p0) v(xcase81.att_p1) v(xcase81.att_p2) v(cctrl81) v(cm81) v(xcase81.inn) v(xcase81.inp) v(inx81) v(iny81) v(xcase81.nbias) v(outn81) v(outp81) v(xcase81.p_bias) v(rctrl81) v(xcase81.s1) v(xcase81.s2) v(vdd81)
ac dec 50 1meg 100g
wrdata ac_084.txt v(outp0) v(outn0) v(vid0) v(outp81) v(outn81) v(vid81)
alter Vr0 1.242
alter Vc0 0.027
op
wrdata op_085.txt i(vsupply0) v(xcase0.att_n0) v(xcase0.att_n1) v(xcase0.att_n2) v(xcase0.att_p0) v(xcase0.att_p1) v(xcase0.att_p2) v(cctrl0) v(cm0) v(xcase0.inn) v(xcase0.inp) v(inx0) v(iny0) v(xcase0.nbias) v(outn0) v(outp0) v(xcase0.p_bias) v(xcase0.rc_ct) v(xcase0.rc_gate) v(xcase0.rc_mid) v(rctrl0) v(xcase0.s1) v(xcase0.s2) v(vdd0) i(vsupply81) v(xcase81.att_n0) v(xcase81.att_n1) v(xcase81.att_n2) v(xcase81.att_p0) v(xcase81.att_p1) v(xcase81.att_p2) v(cctrl81) v(cm81) v(xcase81.inn) v(xcase81.inp) v(inx81) v(iny81) v(xcase81.nbias) v(outn81) v(outp81) v(xcase81.p_bias) v(rctrl81) v(xcase81.s1) v(xcase81.s2) v(vdd81)
ac dec 50 1meg 100g
wrdata ac_085.txt v(outp0) v(outn0) v(vid0) v(outp81) v(outn81) v(vid81)
alter Vr0 1.242
alter Vc0 0.054
op
wrdata op_086.txt i(vsupply0) v(xcase0.att_n0) v(xcase0.att_n1) v(xcase0.att_n2) v(xcase0.att_p0) v(xcase0.att_p1) v(xcase0.att_p2) v(cctrl0) v(cm0) v(xcase0.inn) v(xcase0.inp) v(inx0) v(iny0) v(xcase0.nbias) v(outn0) v(outp0) v(xcase0.p_bias) v(xcase0.rc_ct) v(xcase0.rc_gate) v(xcase0.rc_mid) v(rctrl0) v(xcase0.s1) v(xcase0.s2) v(vdd0) i(vsupply81) v(xcase81.att_n0) v(xcase81.att_n1) v(xcase81.att_n2) v(xcase81.att_p0) v(xcase81.att_p1) v(xcase81.att_p2) v(cctrl81) v(cm81) v(xcase81.inn) v(xcase81.inp) v(inx81) v(iny81) v(xcase81.nbias) v(outn81) v(outp81) v(xcase81.p_bias) v(rctrl81) v(xcase81.s1) v(xcase81.s2) v(vdd81)
ac dec 50 1meg 100g
wrdata ac_086.txt v(outp0) v(outn0) v(vid0) v(outp81) v(outn81) v(vid81)
alter Vr0 1.242
alter Vc0 0.081
op
wrdata op_087.txt i(vsupply0) v(xcase0.att_n0) v(xcase0.att_n1) v(xcase0.att_n2) v(xcase0.att_p0) v(xcase0.att_p1) v(xcase0.att_p2) v(cctrl0) v(cm0) v(xcase0.inn) v(xcase0.inp) v(inx0) v(iny0) v(xcase0.nbias) v(outn0) v(outp0) v(xcase0.p_bias) v(xcase0.rc_ct) v(xcase0.rc_gate) v(xcase0.rc_mid) v(rctrl0) v(xcase0.s1) v(xcase0.s2) v(vdd0) i(vsupply81) v(xcase81.att_n0) v(xcase81.att_n1) v(xcase81.att_n2) v(xcase81.att_p0) v(xcase81.att_p1) v(xcase81.att_p2) v(cctrl81) v(cm81) v(xcase81.inn) v(xcase81.inp) v(inx81) v(iny81) v(xcase81.nbias) v(outn81) v(outp81) v(xcase81.p_bias) v(rctrl81) v(xcase81.s1) v(xcase81.s2) v(vdd81)
ac dec 50 1meg 100g
wrdata ac_087.txt v(outp0) v(outn0) v(vid0) v(outp81) v(outn81) v(vid81)
alter Vr0 1.242
alter Vc0 0.108
op
wrdata op_088.txt i(vsupply0) v(xcase0.att_n0) v(xcase0.att_n1) v(xcase0.att_n2) v(xcase0.att_p0) v(xcase0.att_p1) v(xcase0.att_p2) v(cctrl0) v(cm0) v(xcase0.inn) v(xcase0.inp) v(inx0) v(iny0) v(xcase0.nbias) v(outn0) v(outp0) v(xcase0.p_bias) v(xcase0.rc_ct) v(xcase0.rc_gate) v(xcase0.rc_mid) v(rctrl0) v(xcase0.s1) v(xcase0.s2) v(vdd0) i(vsupply81) v(xcase81.att_n0) v(xcase81.att_n1) v(xcase81.att_n2) v(xcase81.att_p0) v(xcase81.att_p1) v(xcase81.att_p2) v(cctrl81) v(cm81) v(xcase81.inn) v(xcase81.inp) v(inx81) v(iny81) v(xcase81.nbias) v(outn81) v(outp81) v(xcase81.p_bias) v(rctrl81) v(xcase81.s1) v(xcase81.s2) v(vdd81)
ac dec 50 1meg 100g
wrdata ac_088.txt v(outp0) v(outn0) v(vid0) v(outp81) v(outn81) v(vid81)
alter Vr0 1.242
alter Vc0 0.135
op
wrdata op_089.txt i(vsupply0) v(xcase0.att_n0) v(xcase0.att_n1) v(xcase0.att_n2) v(xcase0.att_p0) v(xcase0.att_p1) v(xcase0.att_p2) v(cctrl0) v(cm0) v(xcase0.inn) v(xcase0.inp) v(inx0) v(iny0) v(xcase0.nbias) v(outn0) v(outp0) v(xcase0.p_bias) v(xcase0.rc_ct) v(xcase0.rc_gate) v(xcase0.rc_mid) v(rctrl0) v(xcase0.s1) v(xcase0.s2) v(vdd0) i(vsupply81) v(xcase81.att_n0) v(xcase81.att_n1) v(xcase81.att_n2) v(xcase81.att_p0) v(xcase81.att_p1) v(xcase81.att_p2) v(cctrl81) v(cm81) v(xcase81.inn) v(xcase81.inp) v(inx81) v(iny81) v(xcase81.nbias) v(outn81) v(outp81) v(xcase81.p_bias) v(rctrl81) v(xcase81.s1) v(xcase81.s2) v(vdd81)
ac dec 50 1meg 100g
wrdata ac_089.txt v(outp0) v(outn0) v(vid0) v(outp81) v(outn81) v(vid81)
alter Vr0 1.242
alter Vc0 0.162
op
wrdata op_090.txt i(vsupply0) v(xcase0.att_n0) v(xcase0.att_n1) v(xcase0.att_n2) v(xcase0.att_p0) v(xcase0.att_p1) v(xcase0.att_p2) v(cctrl0) v(cm0) v(xcase0.inn) v(xcase0.inp) v(inx0) v(iny0) v(xcase0.nbias) v(outn0) v(outp0) v(xcase0.p_bias) v(xcase0.rc_ct) v(xcase0.rc_gate) v(xcase0.rc_mid) v(rctrl0) v(xcase0.s1) v(xcase0.s2) v(vdd0) i(vsupply81) v(xcase81.att_n0) v(xcase81.att_n1) v(xcase81.att_n2) v(xcase81.att_p0) v(xcase81.att_p1) v(xcase81.att_p2) v(cctrl81) v(cm81) v(xcase81.inn) v(xcase81.inp) v(inx81) v(iny81) v(xcase81.nbias) v(outn81) v(outp81) v(xcase81.p_bias) v(rctrl81) v(xcase81.s1) v(xcase81.s2) v(vdd81)
ac dec 50 1meg 100g
wrdata ac_090.txt v(outp0) v(outn0) v(vid0) v(outp81) v(outn81) v(vid81)
alter Vr0 1.242
alter Vc0 0.189
op
wrdata op_091.txt i(vsupply0) v(xcase0.att_n0) v(xcase0.att_n1) v(xcase0.att_n2) v(xcase0.att_p0) v(xcase0.att_p1) v(xcase0.att_p2) v(cctrl0) v(cm0) v(xcase0.inn) v(xcase0.inp) v(inx0) v(iny0) v(xcase0.nbias) v(outn0) v(outp0) v(xcase0.p_bias) v(xcase0.rc_ct) v(xcase0.rc_gate) v(xcase0.rc_mid) v(rctrl0) v(xcase0.s1) v(xcase0.s2) v(vdd0) i(vsupply81) v(xcase81.att_n0) v(xcase81.att_n1) v(xcase81.att_n2) v(xcase81.att_p0) v(xcase81.att_p1) v(xcase81.att_p2) v(cctrl81) v(cm81) v(xcase81.inn) v(xcase81.inp) v(inx81) v(iny81) v(xcase81.nbias) v(outn81) v(outp81) v(xcase81.p_bias) v(rctrl81) v(xcase81.s1) v(xcase81.s2) v(vdd81)
ac dec 50 1meg 100g
wrdata ac_091.txt v(outp0) v(outn0) v(vid0) v(outp81) v(outn81) v(vid81)
alter Vr0 1.242
alter Vc0 0.216
op
wrdata op_092.txt i(vsupply0) v(xcase0.att_n0) v(xcase0.att_n1) v(xcase0.att_n2) v(xcase0.att_p0) v(xcase0.att_p1) v(xcase0.att_p2) v(cctrl0) v(cm0) v(xcase0.inn) v(xcase0.inp) v(inx0) v(iny0) v(xcase0.nbias) v(outn0) v(outp0) v(xcase0.p_bias) v(xcase0.rc_ct) v(xcase0.rc_gate) v(xcase0.rc_mid) v(rctrl0) v(xcase0.s1) v(xcase0.s2) v(vdd0) i(vsupply81) v(xcase81.att_n0) v(xcase81.att_n1) v(xcase81.att_n2) v(xcase81.att_p0) v(xcase81.att_p1) v(xcase81.att_p2) v(cctrl81) v(cm81) v(xcase81.inn) v(xcase81.inp) v(inx81) v(iny81) v(xcase81.nbias) v(outn81) v(outp81) v(xcase81.p_bias) v(rctrl81) v(xcase81.s1) v(xcase81.s2) v(vdd81)
ac dec 50 1meg 100g
wrdata ac_092.txt v(outp0) v(outn0) v(vid0) v(outp81) v(outn81) v(vid81)
alter Vr0 1.242
alter Vc0 0.243
op
wrdata op_093.txt i(vsupply0) v(xcase0.att_n0) v(xcase0.att_n1) v(xcase0.att_n2) v(xcase0.att_p0) v(xcase0.att_p1) v(xcase0.att_p2) v(cctrl0) v(cm0) v(xcase0.inn) v(xcase0.inp) v(inx0) v(iny0) v(xcase0.nbias) v(outn0) v(outp0) v(xcase0.p_bias) v(xcase0.rc_ct) v(xcase0.rc_gate) v(xcase0.rc_mid) v(rctrl0) v(xcase0.s1) v(xcase0.s2) v(vdd0) i(vsupply81) v(xcase81.att_n0) v(xcase81.att_n1) v(xcase81.att_n2) v(xcase81.att_p0) v(xcase81.att_p1) v(xcase81.att_p2) v(cctrl81) v(cm81) v(xcase81.inn) v(xcase81.inp) v(inx81) v(iny81) v(xcase81.nbias) v(outn81) v(outp81) v(xcase81.p_bias) v(rctrl81) v(xcase81.s1) v(xcase81.s2) v(vdd81)
ac dec 50 1meg 100g
wrdata ac_093.txt v(outp0) v(outn0) v(vid0) v(outp81) v(outn81) v(vid81)
alter Vr0 1.242
alter Vc0 0.27
op
wrdata op_094.txt i(vsupply0) v(xcase0.att_n0) v(xcase0.att_n1) v(xcase0.att_n2) v(xcase0.att_p0) v(xcase0.att_p1) v(xcase0.att_p2) v(cctrl0) v(cm0) v(xcase0.inn) v(xcase0.inp) v(inx0) v(iny0) v(xcase0.nbias) v(outn0) v(outp0) v(xcase0.p_bias) v(xcase0.rc_ct) v(xcase0.rc_gate) v(xcase0.rc_mid) v(rctrl0) v(xcase0.s1) v(xcase0.s2) v(vdd0) i(vsupply81) v(xcase81.att_n0) v(xcase81.att_n1) v(xcase81.att_n2) v(xcase81.att_p0) v(xcase81.att_p1) v(xcase81.att_p2) v(cctrl81) v(cm81) v(xcase81.inn) v(xcase81.inp) v(inx81) v(iny81) v(xcase81.nbias) v(outn81) v(outp81) v(xcase81.p_bias) v(rctrl81) v(xcase81.s1) v(xcase81.s2) v(vdd81)
ac dec 50 1meg 100g
wrdata ac_094.txt v(outp0) v(outn0) v(vid0) v(outp81) v(outn81) v(vid81)
alter Vr0 1.242
alter Vc0 0.297
op
wrdata op_095.txt i(vsupply0) v(xcase0.att_n0) v(xcase0.att_n1) v(xcase0.att_n2) v(xcase0.att_p0) v(xcase0.att_p1) v(xcase0.att_p2) v(cctrl0) v(cm0) v(xcase0.inn) v(xcase0.inp) v(inx0) v(iny0) v(xcase0.nbias) v(outn0) v(outp0) v(xcase0.p_bias) v(xcase0.rc_ct) v(xcase0.rc_gate) v(xcase0.rc_mid) v(rctrl0) v(xcase0.s1) v(xcase0.s2) v(vdd0) i(vsupply81) v(xcase81.att_n0) v(xcase81.att_n1) v(xcase81.att_n2) v(xcase81.att_p0) v(xcase81.att_p1) v(xcase81.att_p2) v(cctrl81) v(cm81) v(xcase81.inn) v(xcase81.inp) v(inx81) v(iny81) v(xcase81.nbias) v(outn81) v(outp81) v(xcase81.p_bias) v(rctrl81) v(xcase81.s1) v(xcase81.s2) v(vdd81)
ac dec 50 1meg 100g
wrdata ac_095.txt v(outp0) v(outn0) v(vid0) v(outp81) v(outn81) v(vid81)
alter Vr0 1.242
alter Vc0 0.324
op
wrdata op_096.txt i(vsupply0) v(xcase0.att_n0) v(xcase0.att_n1) v(xcase0.att_n2) v(xcase0.att_p0) v(xcase0.att_p1) v(xcase0.att_p2) v(cctrl0) v(cm0) v(xcase0.inn) v(xcase0.inp) v(inx0) v(iny0) v(xcase0.nbias) v(outn0) v(outp0) v(xcase0.p_bias) v(xcase0.rc_ct) v(xcase0.rc_gate) v(xcase0.rc_mid) v(rctrl0) v(xcase0.s1) v(xcase0.s2) v(vdd0) i(vsupply81) v(xcase81.att_n0) v(xcase81.att_n1) v(xcase81.att_n2) v(xcase81.att_p0) v(xcase81.att_p1) v(xcase81.att_p2) v(cctrl81) v(cm81) v(xcase81.inn) v(xcase81.inp) v(inx81) v(iny81) v(xcase81.nbias) v(outn81) v(outp81) v(xcase81.p_bias) v(rctrl81) v(xcase81.s1) v(xcase81.s2) v(vdd81)
ac dec 50 1meg 100g
wrdata ac_096.txt v(outp0) v(outn0) v(vid0) v(outp81) v(outn81) v(vid81)
alter Vr0 1.242
alter Vc0 0.351
op
wrdata op_097.txt i(vsupply0) v(xcase0.att_n0) v(xcase0.att_n1) v(xcase0.att_n2) v(xcase0.att_p0) v(xcase0.att_p1) v(xcase0.att_p2) v(cctrl0) v(cm0) v(xcase0.inn) v(xcase0.inp) v(inx0) v(iny0) v(xcase0.nbias) v(outn0) v(outp0) v(xcase0.p_bias) v(xcase0.rc_ct) v(xcase0.rc_gate) v(xcase0.rc_mid) v(rctrl0) v(xcase0.s1) v(xcase0.s2) v(vdd0) i(vsupply81) v(xcase81.att_n0) v(xcase81.att_n1) v(xcase81.att_n2) v(xcase81.att_p0) v(xcase81.att_p1) v(xcase81.att_p2) v(cctrl81) v(cm81) v(xcase81.inn) v(xcase81.inp) v(inx81) v(iny81) v(xcase81.nbias) v(outn81) v(outp81) v(xcase81.p_bias) v(rctrl81) v(xcase81.s1) v(xcase81.s2) v(vdd81)
ac dec 50 1meg 100g
wrdata ac_097.txt v(outp0) v(outn0) v(vid0) v(outp81) v(outn81) v(vid81)
alter Vr0 1.242
alter Vc0 0.378
op
wrdata op_098.txt i(vsupply0) v(xcase0.att_n0) v(xcase0.att_n1) v(xcase0.att_n2) v(xcase0.att_p0) v(xcase0.att_p1) v(xcase0.att_p2) v(cctrl0) v(cm0) v(xcase0.inn) v(xcase0.inp) v(inx0) v(iny0) v(xcase0.nbias) v(outn0) v(outp0) v(xcase0.p_bias) v(xcase0.rc_ct) v(xcase0.rc_gate) v(xcase0.rc_mid) v(rctrl0) v(xcase0.s1) v(xcase0.s2) v(vdd0) i(vsupply81) v(xcase81.att_n0) v(xcase81.att_n1) v(xcase81.att_n2) v(xcase81.att_p0) v(xcase81.att_p1) v(xcase81.att_p2) v(cctrl81) v(cm81) v(xcase81.inn) v(xcase81.inp) v(inx81) v(iny81) v(xcase81.nbias) v(outn81) v(outp81) v(xcase81.p_bias) v(rctrl81) v(xcase81.s1) v(xcase81.s2) v(vdd81)
ac dec 50 1meg 100g
wrdata ac_098.txt v(outp0) v(outn0) v(vid0) v(outp81) v(outn81) v(vid81)
alter Vr0 1.242
alter Vc0 0.405
op
wrdata op_099.txt i(vsupply0) v(xcase0.att_n0) v(xcase0.att_n1) v(xcase0.att_n2) v(xcase0.att_p0) v(xcase0.att_p1) v(xcase0.att_p2) v(cctrl0) v(cm0) v(xcase0.inn) v(xcase0.inp) v(inx0) v(iny0) v(xcase0.nbias) v(outn0) v(outp0) v(xcase0.p_bias) v(xcase0.rc_ct) v(xcase0.rc_gate) v(xcase0.rc_mid) v(rctrl0) v(xcase0.s1) v(xcase0.s2) v(vdd0) i(vsupply81) v(xcase81.att_n0) v(xcase81.att_n1) v(xcase81.att_n2) v(xcase81.att_p0) v(xcase81.att_p1) v(xcase81.att_p2) v(cctrl81) v(cm81) v(xcase81.inn) v(xcase81.inp) v(inx81) v(iny81) v(xcase81.nbias) v(outn81) v(outp81) v(xcase81.p_bias) v(rctrl81) v(xcase81.s1) v(xcase81.s2) v(vdd81)
ac dec 50 1meg 100g
wrdata ac_099.txt v(outp0) v(outn0) v(vid0) v(outp81) v(outn81) v(vid81)
alter Vr0 1.242
alter Vc0 0.432
op
wrdata op_100.txt i(vsupply0) v(xcase0.att_n0) v(xcase0.att_n1) v(xcase0.att_n2) v(xcase0.att_p0) v(xcase0.att_p1) v(xcase0.att_p2) v(cctrl0) v(cm0) v(xcase0.inn) v(xcase0.inp) v(inx0) v(iny0) v(xcase0.nbias) v(outn0) v(outp0) v(xcase0.p_bias) v(xcase0.rc_ct) v(xcase0.rc_gate) v(xcase0.rc_mid) v(rctrl0) v(xcase0.s1) v(xcase0.s2) v(vdd0) i(vsupply81) v(xcase81.att_n0) v(xcase81.att_n1) v(xcase81.att_n2) v(xcase81.att_p0) v(xcase81.att_p1) v(xcase81.att_p2) v(cctrl81) v(cm81) v(xcase81.inn) v(xcase81.inp) v(inx81) v(iny81) v(xcase81.nbias) v(outn81) v(outp81) v(xcase81.p_bias) v(rctrl81) v(xcase81.s1) v(xcase81.s2) v(vdd81)
ac dec 50 1meg 100g
wrdata ac_100.txt v(outp0) v(outn0) v(vid0) v(outp81) v(outn81) v(vid81)
alter Vr0 1.242
alter Vc0 0.459
op
wrdata op_101.txt i(vsupply0) v(xcase0.att_n0) v(xcase0.att_n1) v(xcase0.att_n2) v(xcase0.att_p0) v(xcase0.att_p1) v(xcase0.att_p2) v(cctrl0) v(cm0) v(xcase0.inn) v(xcase0.inp) v(inx0) v(iny0) v(xcase0.nbias) v(outn0) v(outp0) v(xcase0.p_bias) v(xcase0.rc_ct) v(xcase0.rc_gate) v(xcase0.rc_mid) v(rctrl0) v(xcase0.s1) v(xcase0.s2) v(vdd0) i(vsupply81) v(xcase81.att_n0) v(xcase81.att_n1) v(xcase81.att_n2) v(xcase81.att_p0) v(xcase81.att_p1) v(xcase81.att_p2) v(cctrl81) v(cm81) v(xcase81.inn) v(xcase81.inp) v(inx81) v(iny81) v(xcase81.nbias) v(outn81) v(outp81) v(xcase81.p_bias) v(rctrl81) v(xcase81.s1) v(xcase81.s2) v(vdd81)
ac dec 50 1meg 100g
wrdata ac_101.txt v(outp0) v(outn0) v(vid0) v(outp81) v(outn81) v(vid81)
alter Vr0 1.242
alter Vc0 0.486
op
wrdata op_102.txt i(vsupply0) v(xcase0.att_n0) v(xcase0.att_n1) v(xcase0.att_n2) v(xcase0.att_p0) v(xcase0.att_p1) v(xcase0.att_p2) v(cctrl0) v(cm0) v(xcase0.inn) v(xcase0.inp) v(inx0) v(iny0) v(xcase0.nbias) v(outn0) v(outp0) v(xcase0.p_bias) v(xcase0.rc_ct) v(xcase0.rc_gate) v(xcase0.rc_mid) v(rctrl0) v(xcase0.s1) v(xcase0.s2) v(vdd0) i(vsupply81) v(xcase81.att_n0) v(xcase81.att_n1) v(xcase81.att_n2) v(xcase81.att_p0) v(xcase81.att_p1) v(xcase81.att_p2) v(cctrl81) v(cm81) v(xcase81.inn) v(xcase81.inp) v(inx81) v(iny81) v(xcase81.nbias) v(outn81) v(outp81) v(xcase81.p_bias) v(rctrl81) v(xcase81.s1) v(xcase81.s2) v(vdd81)
ac dec 50 1meg 100g
wrdata ac_102.txt v(outp0) v(outn0) v(vid0) v(outp81) v(outn81) v(vid81)
alter Vr0 1.242
alter Vc0 0.513
op
wrdata op_103.txt i(vsupply0) v(xcase0.att_n0) v(xcase0.att_n1) v(xcase0.att_n2) v(xcase0.att_p0) v(xcase0.att_p1) v(xcase0.att_p2) v(cctrl0) v(cm0) v(xcase0.inn) v(xcase0.inp) v(inx0) v(iny0) v(xcase0.nbias) v(outn0) v(outp0) v(xcase0.p_bias) v(xcase0.rc_ct) v(xcase0.rc_gate) v(xcase0.rc_mid) v(rctrl0) v(xcase0.s1) v(xcase0.s2) v(vdd0) i(vsupply81) v(xcase81.att_n0) v(xcase81.att_n1) v(xcase81.att_n2) v(xcase81.att_p0) v(xcase81.att_p1) v(xcase81.att_p2) v(cctrl81) v(cm81) v(xcase81.inn) v(xcase81.inp) v(inx81) v(iny81) v(xcase81.nbias) v(outn81) v(outp81) v(xcase81.p_bias) v(rctrl81) v(xcase81.s1) v(xcase81.s2) v(vdd81)
ac dec 50 1meg 100g
wrdata ac_103.txt v(outp0) v(outn0) v(vid0) v(outp81) v(outn81) v(vid81)
alter Vr0 1.242
alter Vc0 0.54
op
wrdata op_104.txt i(vsupply0) v(xcase0.att_n0) v(xcase0.att_n1) v(xcase0.att_n2) v(xcase0.att_p0) v(xcase0.att_p1) v(xcase0.att_p2) v(cctrl0) v(cm0) v(xcase0.inn) v(xcase0.inp) v(inx0) v(iny0) v(xcase0.nbias) v(outn0) v(outp0) v(xcase0.p_bias) v(xcase0.rc_ct) v(xcase0.rc_gate) v(xcase0.rc_mid) v(rctrl0) v(xcase0.s1) v(xcase0.s2) v(vdd0) i(vsupply81) v(xcase81.att_n0) v(xcase81.att_n1) v(xcase81.att_n2) v(xcase81.att_p0) v(xcase81.att_p1) v(xcase81.att_p2) v(cctrl81) v(cm81) v(xcase81.inn) v(xcase81.inp) v(inx81) v(iny81) v(xcase81.nbias) v(outn81) v(outp81) v(xcase81.p_bias) v(rctrl81) v(xcase81.s1) v(xcase81.s2) v(vdd81)
ac dec 50 1meg 100g
wrdata ac_104.txt v(outp0) v(outn0) v(vid0) v(outp81) v(outn81) v(vid81)
alter Vr0 1.26
alter Vc0 0
op
wrdata op_105.txt i(vsupply0) v(xcase0.att_n0) v(xcase0.att_n1) v(xcase0.att_n2) v(xcase0.att_p0) v(xcase0.att_p1) v(xcase0.att_p2) v(cctrl0) v(cm0) v(xcase0.inn) v(xcase0.inp) v(inx0) v(iny0) v(xcase0.nbias) v(outn0) v(outp0) v(xcase0.p_bias) v(xcase0.rc_ct) v(xcase0.rc_gate) v(xcase0.rc_mid) v(rctrl0) v(xcase0.s1) v(xcase0.s2) v(vdd0) i(vsupply81) v(xcase81.att_n0) v(xcase81.att_n1) v(xcase81.att_n2) v(xcase81.att_p0) v(xcase81.att_p1) v(xcase81.att_p2) v(cctrl81) v(cm81) v(xcase81.inn) v(xcase81.inp) v(inx81) v(iny81) v(xcase81.nbias) v(outn81) v(outp81) v(xcase81.p_bias) v(rctrl81) v(xcase81.s1) v(xcase81.s2) v(vdd81)
ac dec 50 1meg 100g
wrdata ac_105.txt v(outp0) v(outn0) v(vid0) v(outp81) v(outn81) v(vid81)
alter Vr0 1.26
alter Vc0 0.027
op
wrdata op_106.txt i(vsupply0) v(xcase0.att_n0) v(xcase0.att_n1) v(xcase0.att_n2) v(xcase0.att_p0) v(xcase0.att_p1) v(xcase0.att_p2) v(cctrl0) v(cm0) v(xcase0.inn) v(xcase0.inp) v(inx0) v(iny0) v(xcase0.nbias) v(outn0) v(outp0) v(xcase0.p_bias) v(xcase0.rc_ct) v(xcase0.rc_gate) v(xcase0.rc_mid) v(rctrl0) v(xcase0.s1) v(xcase0.s2) v(vdd0) i(vsupply81) v(xcase81.att_n0) v(xcase81.att_n1) v(xcase81.att_n2) v(xcase81.att_p0) v(xcase81.att_p1) v(xcase81.att_p2) v(cctrl81) v(cm81) v(xcase81.inn) v(xcase81.inp) v(inx81) v(iny81) v(xcase81.nbias) v(outn81) v(outp81) v(xcase81.p_bias) v(rctrl81) v(xcase81.s1) v(xcase81.s2) v(vdd81)
ac dec 50 1meg 100g
wrdata ac_106.txt v(outp0) v(outn0) v(vid0) v(outp81) v(outn81) v(vid81)
alter Vr0 1.26
alter Vc0 0.054
op
wrdata op_107.txt i(vsupply0) v(xcase0.att_n0) v(xcase0.att_n1) v(xcase0.att_n2) v(xcase0.att_p0) v(xcase0.att_p1) v(xcase0.att_p2) v(cctrl0) v(cm0) v(xcase0.inn) v(xcase0.inp) v(inx0) v(iny0) v(xcase0.nbias) v(outn0) v(outp0) v(xcase0.p_bias) v(xcase0.rc_ct) v(xcase0.rc_gate) v(xcase0.rc_mid) v(rctrl0) v(xcase0.s1) v(xcase0.s2) v(vdd0) i(vsupply81) v(xcase81.att_n0) v(xcase81.att_n1) v(xcase81.att_n2) v(xcase81.att_p0) v(xcase81.att_p1) v(xcase81.att_p2) v(cctrl81) v(cm81) v(xcase81.inn) v(xcase81.inp) v(inx81) v(iny81) v(xcase81.nbias) v(outn81) v(outp81) v(xcase81.p_bias) v(rctrl81) v(xcase81.s1) v(xcase81.s2) v(vdd81)
ac dec 50 1meg 100g
wrdata ac_107.txt v(outp0) v(outn0) v(vid0) v(outp81) v(outn81) v(vid81)
alter Vr0 1.26
alter Vc0 0.081
op
wrdata op_108.txt i(vsupply0) v(xcase0.att_n0) v(xcase0.att_n1) v(xcase0.att_n2) v(xcase0.att_p0) v(xcase0.att_p1) v(xcase0.att_p2) v(cctrl0) v(cm0) v(xcase0.inn) v(xcase0.inp) v(inx0) v(iny0) v(xcase0.nbias) v(outn0) v(outp0) v(xcase0.p_bias) v(xcase0.rc_ct) v(xcase0.rc_gate) v(xcase0.rc_mid) v(rctrl0) v(xcase0.s1) v(xcase0.s2) v(vdd0) i(vsupply81) v(xcase81.att_n0) v(xcase81.att_n1) v(xcase81.att_n2) v(xcase81.att_p0) v(xcase81.att_p1) v(xcase81.att_p2) v(cctrl81) v(cm81) v(xcase81.inn) v(xcase81.inp) v(inx81) v(iny81) v(xcase81.nbias) v(outn81) v(outp81) v(xcase81.p_bias) v(rctrl81) v(xcase81.s1) v(xcase81.s2) v(vdd81)
ac dec 50 1meg 100g
wrdata ac_108.txt v(outp0) v(outn0) v(vid0) v(outp81) v(outn81) v(vid81)
alter Vr0 1.26
alter Vc0 0.108
op
wrdata op_109.txt i(vsupply0) v(xcase0.att_n0) v(xcase0.att_n1) v(xcase0.att_n2) v(xcase0.att_p0) v(xcase0.att_p1) v(xcase0.att_p2) v(cctrl0) v(cm0) v(xcase0.inn) v(xcase0.inp) v(inx0) v(iny0) v(xcase0.nbias) v(outn0) v(outp0) v(xcase0.p_bias) v(xcase0.rc_ct) v(xcase0.rc_gate) v(xcase0.rc_mid) v(rctrl0) v(xcase0.s1) v(xcase0.s2) v(vdd0) i(vsupply81) v(xcase81.att_n0) v(xcase81.att_n1) v(xcase81.att_n2) v(xcase81.att_p0) v(xcase81.att_p1) v(xcase81.att_p2) v(cctrl81) v(cm81) v(xcase81.inn) v(xcase81.inp) v(inx81) v(iny81) v(xcase81.nbias) v(outn81) v(outp81) v(xcase81.p_bias) v(rctrl81) v(xcase81.s1) v(xcase81.s2) v(vdd81)
ac dec 50 1meg 100g
wrdata ac_109.txt v(outp0) v(outn0) v(vid0) v(outp81) v(outn81) v(vid81)
alter Vr0 1.26
alter Vc0 0.135
op
wrdata op_110.txt i(vsupply0) v(xcase0.att_n0) v(xcase0.att_n1) v(xcase0.att_n2) v(xcase0.att_p0) v(xcase0.att_p1) v(xcase0.att_p2) v(cctrl0) v(cm0) v(xcase0.inn) v(xcase0.inp) v(inx0) v(iny0) v(xcase0.nbias) v(outn0) v(outp0) v(xcase0.p_bias) v(xcase0.rc_ct) v(xcase0.rc_gate) v(xcase0.rc_mid) v(rctrl0) v(xcase0.s1) v(xcase0.s2) v(vdd0) i(vsupply81) v(xcase81.att_n0) v(xcase81.att_n1) v(xcase81.att_n2) v(xcase81.att_p0) v(xcase81.att_p1) v(xcase81.att_p2) v(cctrl81) v(cm81) v(xcase81.inn) v(xcase81.inp) v(inx81) v(iny81) v(xcase81.nbias) v(outn81) v(outp81) v(xcase81.p_bias) v(rctrl81) v(xcase81.s1) v(xcase81.s2) v(vdd81)
ac dec 50 1meg 100g
wrdata ac_110.txt v(outp0) v(outn0) v(vid0) v(outp81) v(outn81) v(vid81)
alter Vr0 1.26
alter Vc0 0.162
op
wrdata op_111.txt i(vsupply0) v(xcase0.att_n0) v(xcase0.att_n1) v(xcase0.att_n2) v(xcase0.att_p0) v(xcase0.att_p1) v(xcase0.att_p2) v(cctrl0) v(cm0) v(xcase0.inn) v(xcase0.inp) v(inx0) v(iny0) v(xcase0.nbias) v(outn0) v(outp0) v(xcase0.p_bias) v(xcase0.rc_ct) v(xcase0.rc_gate) v(xcase0.rc_mid) v(rctrl0) v(xcase0.s1) v(xcase0.s2) v(vdd0) i(vsupply81) v(xcase81.att_n0) v(xcase81.att_n1) v(xcase81.att_n2) v(xcase81.att_p0) v(xcase81.att_p1) v(xcase81.att_p2) v(cctrl81) v(cm81) v(xcase81.inn) v(xcase81.inp) v(inx81) v(iny81) v(xcase81.nbias) v(outn81) v(outp81) v(xcase81.p_bias) v(rctrl81) v(xcase81.s1) v(xcase81.s2) v(vdd81)
ac dec 50 1meg 100g
wrdata ac_111.txt v(outp0) v(outn0) v(vid0) v(outp81) v(outn81) v(vid81)
alter Vr0 1.26
alter Vc0 0.189
op
wrdata op_112.txt i(vsupply0) v(xcase0.att_n0) v(xcase0.att_n1) v(xcase0.att_n2) v(xcase0.att_p0) v(xcase0.att_p1) v(xcase0.att_p2) v(cctrl0) v(cm0) v(xcase0.inn) v(xcase0.inp) v(inx0) v(iny0) v(xcase0.nbias) v(outn0) v(outp0) v(xcase0.p_bias) v(xcase0.rc_ct) v(xcase0.rc_gate) v(xcase0.rc_mid) v(rctrl0) v(xcase0.s1) v(xcase0.s2) v(vdd0) i(vsupply81) v(xcase81.att_n0) v(xcase81.att_n1) v(xcase81.att_n2) v(xcase81.att_p0) v(xcase81.att_p1) v(xcase81.att_p2) v(cctrl81) v(cm81) v(xcase81.inn) v(xcase81.inp) v(inx81) v(iny81) v(xcase81.nbias) v(outn81) v(outp81) v(xcase81.p_bias) v(rctrl81) v(xcase81.s1) v(xcase81.s2) v(vdd81)
ac dec 50 1meg 100g
wrdata ac_112.txt v(outp0) v(outn0) v(vid0) v(outp81) v(outn81) v(vid81)
alter Vr0 1.26
alter Vc0 0.216
op
wrdata op_113.txt i(vsupply0) v(xcase0.att_n0) v(xcase0.att_n1) v(xcase0.att_n2) v(xcase0.att_p0) v(xcase0.att_p1) v(xcase0.att_p2) v(cctrl0) v(cm0) v(xcase0.inn) v(xcase0.inp) v(inx0) v(iny0) v(xcase0.nbias) v(outn0) v(outp0) v(xcase0.p_bias) v(xcase0.rc_ct) v(xcase0.rc_gate) v(xcase0.rc_mid) v(rctrl0) v(xcase0.s1) v(xcase0.s2) v(vdd0) i(vsupply81) v(xcase81.att_n0) v(xcase81.att_n1) v(xcase81.att_n2) v(xcase81.att_p0) v(xcase81.att_p1) v(xcase81.att_p2) v(cctrl81) v(cm81) v(xcase81.inn) v(xcase81.inp) v(inx81) v(iny81) v(xcase81.nbias) v(outn81) v(outp81) v(xcase81.p_bias) v(rctrl81) v(xcase81.s1) v(xcase81.s2) v(vdd81)
ac dec 50 1meg 100g
wrdata ac_113.txt v(outp0) v(outn0) v(vid0) v(outp81) v(outn81) v(vid81)
alter Vr0 1.26
alter Vc0 0.243
op
wrdata op_114.txt i(vsupply0) v(xcase0.att_n0) v(xcase0.att_n1) v(xcase0.att_n2) v(xcase0.att_p0) v(xcase0.att_p1) v(xcase0.att_p2) v(cctrl0) v(cm0) v(xcase0.inn) v(xcase0.inp) v(inx0) v(iny0) v(xcase0.nbias) v(outn0) v(outp0) v(xcase0.p_bias) v(xcase0.rc_ct) v(xcase0.rc_gate) v(xcase0.rc_mid) v(rctrl0) v(xcase0.s1) v(xcase0.s2) v(vdd0) i(vsupply81) v(xcase81.att_n0) v(xcase81.att_n1) v(xcase81.att_n2) v(xcase81.att_p0) v(xcase81.att_p1) v(xcase81.att_p2) v(cctrl81) v(cm81) v(xcase81.inn) v(xcase81.inp) v(inx81) v(iny81) v(xcase81.nbias) v(outn81) v(outp81) v(xcase81.p_bias) v(rctrl81) v(xcase81.s1) v(xcase81.s2) v(vdd81)
ac dec 50 1meg 100g
wrdata ac_114.txt v(outp0) v(outn0) v(vid0) v(outp81) v(outn81) v(vid81)
alter Vr0 1.26
alter Vc0 0.27
op
wrdata op_115.txt i(vsupply0) v(xcase0.att_n0) v(xcase0.att_n1) v(xcase0.att_n2) v(xcase0.att_p0) v(xcase0.att_p1) v(xcase0.att_p2) v(cctrl0) v(cm0) v(xcase0.inn) v(xcase0.inp) v(inx0) v(iny0) v(xcase0.nbias) v(outn0) v(outp0) v(xcase0.p_bias) v(xcase0.rc_ct) v(xcase0.rc_gate) v(xcase0.rc_mid) v(rctrl0) v(xcase0.s1) v(xcase0.s2) v(vdd0) i(vsupply81) v(xcase81.att_n0) v(xcase81.att_n1) v(xcase81.att_n2) v(xcase81.att_p0) v(xcase81.att_p1) v(xcase81.att_p2) v(cctrl81) v(cm81) v(xcase81.inn) v(xcase81.inp) v(inx81) v(iny81) v(xcase81.nbias) v(outn81) v(outp81) v(xcase81.p_bias) v(rctrl81) v(xcase81.s1) v(xcase81.s2) v(vdd81)
ac dec 50 1meg 100g
wrdata ac_115.txt v(outp0) v(outn0) v(vid0) v(outp81) v(outn81) v(vid81)
alter Vr0 1.26
alter Vc0 0.297
op
wrdata op_116.txt i(vsupply0) v(xcase0.att_n0) v(xcase0.att_n1) v(xcase0.att_n2) v(xcase0.att_p0) v(xcase0.att_p1) v(xcase0.att_p2) v(cctrl0) v(cm0) v(xcase0.inn) v(xcase0.inp) v(inx0) v(iny0) v(xcase0.nbias) v(outn0) v(outp0) v(xcase0.p_bias) v(xcase0.rc_ct) v(xcase0.rc_gate) v(xcase0.rc_mid) v(rctrl0) v(xcase0.s1) v(xcase0.s2) v(vdd0) i(vsupply81) v(xcase81.att_n0) v(xcase81.att_n1) v(xcase81.att_n2) v(xcase81.att_p0) v(xcase81.att_p1) v(xcase81.att_p2) v(cctrl81) v(cm81) v(xcase81.inn) v(xcase81.inp) v(inx81) v(iny81) v(xcase81.nbias) v(outn81) v(outp81) v(xcase81.p_bias) v(rctrl81) v(xcase81.s1) v(xcase81.s2) v(vdd81)
ac dec 50 1meg 100g
wrdata ac_116.txt v(outp0) v(outn0) v(vid0) v(outp81) v(outn81) v(vid81)
alter Vr0 1.26
alter Vc0 0.324
op
wrdata op_117.txt i(vsupply0) v(xcase0.att_n0) v(xcase0.att_n1) v(xcase0.att_n2) v(xcase0.att_p0) v(xcase0.att_p1) v(xcase0.att_p2) v(cctrl0) v(cm0) v(xcase0.inn) v(xcase0.inp) v(inx0) v(iny0) v(xcase0.nbias) v(outn0) v(outp0) v(xcase0.p_bias) v(xcase0.rc_ct) v(xcase0.rc_gate) v(xcase0.rc_mid) v(rctrl0) v(xcase0.s1) v(xcase0.s2) v(vdd0) i(vsupply81) v(xcase81.att_n0) v(xcase81.att_n1) v(xcase81.att_n2) v(xcase81.att_p0) v(xcase81.att_p1) v(xcase81.att_p2) v(cctrl81) v(cm81) v(xcase81.inn) v(xcase81.inp) v(inx81) v(iny81) v(xcase81.nbias) v(outn81) v(outp81) v(xcase81.p_bias) v(rctrl81) v(xcase81.s1) v(xcase81.s2) v(vdd81)
ac dec 50 1meg 100g
wrdata ac_117.txt v(outp0) v(outn0) v(vid0) v(outp81) v(outn81) v(vid81)
alter Vr0 1.26
alter Vc0 0.351
op
wrdata op_118.txt i(vsupply0) v(xcase0.att_n0) v(xcase0.att_n1) v(xcase0.att_n2) v(xcase0.att_p0) v(xcase0.att_p1) v(xcase0.att_p2) v(cctrl0) v(cm0) v(xcase0.inn) v(xcase0.inp) v(inx0) v(iny0) v(xcase0.nbias) v(outn0) v(outp0) v(xcase0.p_bias) v(xcase0.rc_ct) v(xcase0.rc_gate) v(xcase0.rc_mid) v(rctrl0) v(xcase0.s1) v(xcase0.s2) v(vdd0) i(vsupply81) v(xcase81.att_n0) v(xcase81.att_n1) v(xcase81.att_n2) v(xcase81.att_p0) v(xcase81.att_p1) v(xcase81.att_p2) v(cctrl81) v(cm81) v(xcase81.inn) v(xcase81.inp) v(inx81) v(iny81) v(xcase81.nbias) v(outn81) v(outp81) v(xcase81.p_bias) v(rctrl81) v(xcase81.s1) v(xcase81.s2) v(vdd81)
ac dec 50 1meg 100g
wrdata ac_118.txt v(outp0) v(outn0) v(vid0) v(outp81) v(outn81) v(vid81)
alter Vr0 1.26
alter Vc0 0.378
op
wrdata op_119.txt i(vsupply0) v(xcase0.att_n0) v(xcase0.att_n1) v(xcase0.att_n2) v(xcase0.att_p0) v(xcase0.att_p1) v(xcase0.att_p2) v(cctrl0) v(cm0) v(xcase0.inn) v(xcase0.inp) v(inx0) v(iny0) v(xcase0.nbias) v(outn0) v(outp0) v(xcase0.p_bias) v(xcase0.rc_ct) v(xcase0.rc_gate) v(xcase0.rc_mid) v(rctrl0) v(xcase0.s1) v(xcase0.s2) v(vdd0) i(vsupply81) v(xcase81.att_n0) v(xcase81.att_n1) v(xcase81.att_n2) v(xcase81.att_p0) v(xcase81.att_p1) v(xcase81.att_p2) v(cctrl81) v(cm81) v(xcase81.inn) v(xcase81.inp) v(inx81) v(iny81) v(xcase81.nbias) v(outn81) v(outp81) v(xcase81.p_bias) v(rctrl81) v(xcase81.s1) v(xcase81.s2) v(vdd81)
ac dec 50 1meg 100g
wrdata ac_119.txt v(outp0) v(outn0) v(vid0) v(outp81) v(outn81) v(vid81)
alter Vr0 1.26
alter Vc0 0.405
op
wrdata op_120.txt i(vsupply0) v(xcase0.att_n0) v(xcase0.att_n1) v(xcase0.att_n2) v(xcase0.att_p0) v(xcase0.att_p1) v(xcase0.att_p2) v(cctrl0) v(cm0) v(xcase0.inn) v(xcase0.inp) v(inx0) v(iny0) v(xcase0.nbias) v(outn0) v(outp0) v(xcase0.p_bias) v(xcase0.rc_ct) v(xcase0.rc_gate) v(xcase0.rc_mid) v(rctrl0) v(xcase0.s1) v(xcase0.s2) v(vdd0) i(vsupply81) v(xcase81.att_n0) v(xcase81.att_n1) v(xcase81.att_n2) v(xcase81.att_p0) v(xcase81.att_p1) v(xcase81.att_p2) v(cctrl81) v(cm81) v(xcase81.inn) v(xcase81.inp) v(inx81) v(iny81) v(xcase81.nbias) v(outn81) v(outp81) v(xcase81.p_bias) v(rctrl81) v(xcase81.s1) v(xcase81.s2) v(vdd81)
ac dec 50 1meg 100g
wrdata ac_120.txt v(outp0) v(outn0) v(vid0) v(outp81) v(outn81) v(vid81)
alter Vr0 1.26
alter Vc0 0.432
op
wrdata op_121.txt i(vsupply0) v(xcase0.att_n0) v(xcase0.att_n1) v(xcase0.att_n2) v(xcase0.att_p0) v(xcase0.att_p1) v(xcase0.att_p2) v(cctrl0) v(cm0) v(xcase0.inn) v(xcase0.inp) v(inx0) v(iny0) v(xcase0.nbias) v(outn0) v(outp0) v(xcase0.p_bias) v(xcase0.rc_ct) v(xcase0.rc_gate) v(xcase0.rc_mid) v(rctrl0) v(xcase0.s1) v(xcase0.s2) v(vdd0) i(vsupply81) v(xcase81.att_n0) v(xcase81.att_n1) v(xcase81.att_n2) v(xcase81.att_p0) v(xcase81.att_p1) v(xcase81.att_p2) v(cctrl81) v(cm81) v(xcase81.inn) v(xcase81.inp) v(inx81) v(iny81) v(xcase81.nbias) v(outn81) v(outp81) v(xcase81.p_bias) v(rctrl81) v(xcase81.s1) v(xcase81.s2) v(vdd81)
ac dec 50 1meg 100g
wrdata ac_121.txt v(outp0) v(outn0) v(vid0) v(outp81) v(outn81) v(vid81)
alter Vr0 1.26
alter Vc0 0.459
op
wrdata op_122.txt i(vsupply0) v(xcase0.att_n0) v(xcase0.att_n1) v(xcase0.att_n2) v(xcase0.att_p0) v(xcase0.att_p1) v(xcase0.att_p2) v(cctrl0) v(cm0) v(xcase0.inn) v(xcase0.inp) v(inx0) v(iny0) v(xcase0.nbias) v(outn0) v(outp0) v(xcase0.p_bias) v(xcase0.rc_ct) v(xcase0.rc_gate) v(xcase0.rc_mid) v(rctrl0) v(xcase0.s1) v(xcase0.s2) v(vdd0) i(vsupply81) v(xcase81.att_n0) v(xcase81.att_n1) v(xcase81.att_n2) v(xcase81.att_p0) v(xcase81.att_p1) v(xcase81.att_p2) v(cctrl81) v(cm81) v(xcase81.inn) v(xcase81.inp) v(inx81) v(iny81) v(xcase81.nbias) v(outn81) v(outp81) v(xcase81.p_bias) v(rctrl81) v(xcase81.s1) v(xcase81.s2) v(vdd81)
ac dec 50 1meg 100g
wrdata ac_122.txt v(outp0) v(outn0) v(vid0) v(outp81) v(outn81) v(vid81)
alter Vr0 1.26
alter Vc0 0.486
op
wrdata op_123.txt i(vsupply0) v(xcase0.att_n0) v(xcase0.att_n1) v(xcase0.att_n2) v(xcase0.att_p0) v(xcase0.att_p1) v(xcase0.att_p2) v(cctrl0) v(cm0) v(xcase0.inn) v(xcase0.inp) v(inx0) v(iny0) v(xcase0.nbias) v(outn0) v(outp0) v(xcase0.p_bias) v(xcase0.rc_ct) v(xcase0.rc_gate) v(xcase0.rc_mid) v(rctrl0) v(xcase0.s1) v(xcase0.s2) v(vdd0) i(vsupply81) v(xcase81.att_n0) v(xcase81.att_n1) v(xcase81.att_n2) v(xcase81.att_p0) v(xcase81.att_p1) v(xcase81.att_p2) v(cctrl81) v(cm81) v(xcase81.inn) v(xcase81.inp) v(inx81) v(iny81) v(xcase81.nbias) v(outn81) v(outp81) v(xcase81.p_bias) v(rctrl81) v(xcase81.s1) v(xcase81.s2) v(vdd81)
ac dec 50 1meg 100g
wrdata ac_123.txt v(outp0) v(outn0) v(vid0) v(outp81) v(outn81) v(vid81)
alter Vr0 1.26
alter Vc0 0.513
op
wrdata op_124.txt i(vsupply0) v(xcase0.att_n0) v(xcase0.att_n1) v(xcase0.att_n2) v(xcase0.att_p0) v(xcase0.att_p1) v(xcase0.att_p2) v(cctrl0) v(cm0) v(xcase0.inn) v(xcase0.inp) v(inx0) v(iny0) v(xcase0.nbias) v(outn0) v(outp0) v(xcase0.p_bias) v(xcase0.rc_ct) v(xcase0.rc_gate) v(xcase0.rc_mid) v(rctrl0) v(xcase0.s1) v(xcase0.s2) v(vdd0) i(vsupply81) v(xcase81.att_n0) v(xcase81.att_n1) v(xcase81.att_n2) v(xcase81.att_p0) v(xcase81.att_p1) v(xcase81.att_p2) v(cctrl81) v(cm81) v(xcase81.inn) v(xcase81.inp) v(inx81) v(iny81) v(xcase81.nbias) v(outn81) v(outp81) v(xcase81.p_bias) v(rctrl81) v(xcase81.s1) v(xcase81.s2) v(vdd81)
ac dec 50 1meg 100g
wrdata ac_124.txt v(outp0) v(outn0) v(vid0) v(outp81) v(outn81) v(vid81)
alter Vr0 1.26
alter Vc0 0.54
op
wrdata op_125.txt i(vsupply0) v(xcase0.att_n0) v(xcase0.att_n1) v(xcase0.att_n2) v(xcase0.att_p0) v(xcase0.att_p1) v(xcase0.att_p2) v(cctrl0) v(cm0) v(xcase0.inn) v(xcase0.inp) v(inx0) v(iny0) v(xcase0.nbias) v(outn0) v(outp0) v(xcase0.p_bias) v(xcase0.rc_ct) v(xcase0.rc_gate) v(xcase0.rc_mid) v(rctrl0) v(xcase0.s1) v(xcase0.s2) v(vdd0) i(vsupply81) v(xcase81.att_n0) v(xcase81.att_n1) v(xcase81.att_n2) v(xcase81.att_p0) v(xcase81.att_p1) v(xcase81.att_p2) v(cctrl81) v(cm81) v(xcase81.inn) v(xcase81.inp) v(inx81) v(iny81) v(xcase81.nbias) v(outn81) v(outp81) v(xcase81.p_bias) v(rctrl81) v(xcase81.s1) v(xcase81.s2) v(vdd81)
ac dec 50 1meg 100g
wrdata ac_125.txt v(outp0) v(outn0) v(vid0) v(outp81) v(outn81) v(vid81)
alter Vr0 1.278
alter Vc0 0
op
wrdata op_126.txt i(vsupply0) v(xcase0.att_n0) v(xcase0.att_n1) v(xcase0.att_n2) v(xcase0.att_p0) v(xcase0.att_p1) v(xcase0.att_p2) v(cctrl0) v(cm0) v(xcase0.inn) v(xcase0.inp) v(inx0) v(iny0) v(xcase0.nbias) v(outn0) v(outp0) v(xcase0.p_bias) v(xcase0.rc_ct) v(xcase0.rc_gate) v(xcase0.rc_mid) v(rctrl0) v(xcase0.s1) v(xcase0.s2) v(vdd0) i(vsupply81) v(xcase81.att_n0) v(xcase81.att_n1) v(xcase81.att_n2) v(xcase81.att_p0) v(xcase81.att_p1) v(xcase81.att_p2) v(cctrl81) v(cm81) v(xcase81.inn) v(xcase81.inp) v(inx81) v(iny81) v(xcase81.nbias) v(outn81) v(outp81) v(xcase81.p_bias) v(rctrl81) v(xcase81.s1) v(xcase81.s2) v(vdd81)
ac dec 50 1meg 100g
wrdata ac_126.txt v(outp0) v(outn0) v(vid0) v(outp81) v(outn81) v(vid81)
alter Vr0 1.278
alter Vc0 0.027
op
wrdata op_127.txt i(vsupply0) v(xcase0.att_n0) v(xcase0.att_n1) v(xcase0.att_n2) v(xcase0.att_p0) v(xcase0.att_p1) v(xcase0.att_p2) v(cctrl0) v(cm0) v(xcase0.inn) v(xcase0.inp) v(inx0) v(iny0) v(xcase0.nbias) v(outn0) v(outp0) v(xcase0.p_bias) v(xcase0.rc_ct) v(xcase0.rc_gate) v(xcase0.rc_mid) v(rctrl0) v(xcase0.s1) v(xcase0.s2) v(vdd0) i(vsupply81) v(xcase81.att_n0) v(xcase81.att_n1) v(xcase81.att_n2) v(xcase81.att_p0) v(xcase81.att_p1) v(xcase81.att_p2) v(cctrl81) v(cm81) v(xcase81.inn) v(xcase81.inp) v(inx81) v(iny81) v(xcase81.nbias) v(outn81) v(outp81) v(xcase81.p_bias) v(rctrl81) v(xcase81.s1) v(xcase81.s2) v(vdd81)
ac dec 50 1meg 100g
wrdata ac_127.txt v(outp0) v(outn0) v(vid0) v(outp81) v(outn81) v(vid81)
alter Vr0 1.278
alter Vc0 0.054
op
wrdata op_128.txt i(vsupply0) v(xcase0.att_n0) v(xcase0.att_n1) v(xcase0.att_n2) v(xcase0.att_p0) v(xcase0.att_p1) v(xcase0.att_p2) v(cctrl0) v(cm0) v(xcase0.inn) v(xcase0.inp) v(inx0) v(iny0) v(xcase0.nbias) v(outn0) v(outp0) v(xcase0.p_bias) v(xcase0.rc_ct) v(xcase0.rc_gate) v(xcase0.rc_mid) v(rctrl0) v(xcase0.s1) v(xcase0.s2) v(vdd0) i(vsupply81) v(xcase81.att_n0) v(xcase81.att_n1) v(xcase81.att_n2) v(xcase81.att_p0) v(xcase81.att_p1) v(xcase81.att_p2) v(cctrl81) v(cm81) v(xcase81.inn) v(xcase81.inp) v(inx81) v(iny81) v(xcase81.nbias) v(outn81) v(outp81) v(xcase81.p_bias) v(rctrl81) v(xcase81.s1) v(xcase81.s2) v(vdd81)
ac dec 50 1meg 100g
wrdata ac_128.txt v(outp0) v(outn0) v(vid0) v(outp81) v(outn81) v(vid81)
alter Vr0 1.278
alter Vc0 0.081
op
wrdata op_129.txt i(vsupply0) v(xcase0.att_n0) v(xcase0.att_n1) v(xcase0.att_n2) v(xcase0.att_p0) v(xcase0.att_p1) v(xcase0.att_p2) v(cctrl0) v(cm0) v(xcase0.inn) v(xcase0.inp) v(inx0) v(iny0) v(xcase0.nbias) v(outn0) v(outp0) v(xcase0.p_bias) v(xcase0.rc_ct) v(xcase0.rc_gate) v(xcase0.rc_mid) v(rctrl0) v(xcase0.s1) v(xcase0.s2) v(vdd0) i(vsupply81) v(xcase81.att_n0) v(xcase81.att_n1) v(xcase81.att_n2) v(xcase81.att_p0) v(xcase81.att_p1) v(xcase81.att_p2) v(cctrl81) v(cm81) v(xcase81.inn) v(xcase81.inp) v(inx81) v(iny81) v(xcase81.nbias) v(outn81) v(outp81) v(xcase81.p_bias) v(rctrl81) v(xcase81.s1) v(xcase81.s2) v(vdd81)
ac dec 50 1meg 100g
wrdata ac_129.txt v(outp0) v(outn0) v(vid0) v(outp81) v(outn81) v(vid81)
alter Vr0 1.278
alter Vc0 0.108
op
wrdata op_130.txt i(vsupply0) v(xcase0.att_n0) v(xcase0.att_n1) v(xcase0.att_n2) v(xcase0.att_p0) v(xcase0.att_p1) v(xcase0.att_p2) v(cctrl0) v(cm0) v(xcase0.inn) v(xcase0.inp) v(inx0) v(iny0) v(xcase0.nbias) v(outn0) v(outp0) v(xcase0.p_bias) v(xcase0.rc_ct) v(xcase0.rc_gate) v(xcase0.rc_mid) v(rctrl0) v(xcase0.s1) v(xcase0.s2) v(vdd0) i(vsupply81) v(xcase81.att_n0) v(xcase81.att_n1) v(xcase81.att_n2) v(xcase81.att_p0) v(xcase81.att_p1) v(xcase81.att_p2) v(cctrl81) v(cm81) v(xcase81.inn) v(xcase81.inp) v(inx81) v(iny81) v(xcase81.nbias) v(outn81) v(outp81) v(xcase81.p_bias) v(rctrl81) v(xcase81.s1) v(xcase81.s2) v(vdd81)
ac dec 50 1meg 100g
wrdata ac_130.txt v(outp0) v(outn0) v(vid0) v(outp81) v(outn81) v(vid81)
alter Vr0 1.278
alter Vc0 0.135
op
wrdata op_131.txt i(vsupply0) v(xcase0.att_n0) v(xcase0.att_n1) v(xcase0.att_n2) v(xcase0.att_p0) v(xcase0.att_p1) v(xcase0.att_p2) v(cctrl0) v(cm0) v(xcase0.inn) v(xcase0.inp) v(inx0) v(iny0) v(xcase0.nbias) v(outn0) v(outp0) v(xcase0.p_bias) v(xcase0.rc_ct) v(xcase0.rc_gate) v(xcase0.rc_mid) v(rctrl0) v(xcase0.s1) v(xcase0.s2) v(vdd0) i(vsupply81) v(xcase81.att_n0) v(xcase81.att_n1) v(xcase81.att_n2) v(xcase81.att_p0) v(xcase81.att_p1) v(xcase81.att_p2) v(cctrl81) v(cm81) v(xcase81.inn) v(xcase81.inp) v(inx81) v(iny81) v(xcase81.nbias) v(outn81) v(outp81) v(xcase81.p_bias) v(rctrl81) v(xcase81.s1) v(xcase81.s2) v(vdd81)
ac dec 50 1meg 100g
wrdata ac_131.txt v(outp0) v(outn0) v(vid0) v(outp81) v(outn81) v(vid81)
alter Vr0 1.278
alter Vc0 0.162
op
wrdata op_132.txt i(vsupply0) v(xcase0.att_n0) v(xcase0.att_n1) v(xcase0.att_n2) v(xcase0.att_p0) v(xcase0.att_p1) v(xcase0.att_p2) v(cctrl0) v(cm0) v(xcase0.inn) v(xcase0.inp) v(inx0) v(iny0) v(xcase0.nbias) v(outn0) v(outp0) v(xcase0.p_bias) v(xcase0.rc_ct) v(xcase0.rc_gate) v(xcase0.rc_mid) v(rctrl0) v(xcase0.s1) v(xcase0.s2) v(vdd0) i(vsupply81) v(xcase81.att_n0) v(xcase81.att_n1) v(xcase81.att_n2) v(xcase81.att_p0) v(xcase81.att_p1) v(xcase81.att_p2) v(cctrl81) v(cm81) v(xcase81.inn) v(xcase81.inp) v(inx81) v(iny81) v(xcase81.nbias) v(outn81) v(outp81) v(xcase81.p_bias) v(rctrl81) v(xcase81.s1) v(xcase81.s2) v(vdd81)
ac dec 50 1meg 100g
wrdata ac_132.txt v(outp0) v(outn0) v(vid0) v(outp81) v(outn81) v(vid81)
alter Vr0 1.278
alter Vc0 0.189
op
wrdata op_133.txt i(vsupply0) v(xcase0.att_n0) v(xcase0.att_n1) v(xcase0.att_n2) v(xcase0.att_p0) v(xcase0.att_p1) v(xcase0.att_p2) v(cctrl0) v(cm0) v(xcase0.inn) v(xcase0.inp) v(inx0) v(iny0) v(xcase0.nbias) v(outn0) v(outp0) v(xcase0.p_bias) v(xcase0.rc_ct) v(xcase0.rc_gate) v(xcase0.rc_mid) v(rctrl0) v(xcase0.s1) v(xcase0.s2) v(vdd0) i(vsupply81) v(xcase81.att_n0) v(xcase81.att_n1) v(xcase81.att_n2) v(xcase81.att_p0) v(xcase81.att_p1) v(xcase81.att_p2) v(cctrl81) v(cm81) v(xcase81.inn) v(xcase81.inp) v(inx81) v(iny81) v(xcase81.nbias) v(outn81) v(outp81) v(xcase81.p_bias) v(rctrl81) v(xcase81.s1) v(xcase81.s2) v(vdd81)
ac dec 50 1meg 100g
wrdata ac_133.txt v(outp0) v(outn0) v(vid0) v(outp81) v(outn81) v(vid81)
alter Vr0 1.278
alter Vc0 0.216
op
wrdata op_134.txt i(vsupply0) v(xcase0.att_n0) v(xcase0.att_n1) v(xcase0.att_n2) v(xcase0.att_p0) v(xcase0.att_p1) v(xcase0.att_p2) v(cctrl0) v(cm0) v(xcase0.inn) v(xcase0.inp) v(inx0) v(iny0) v(xcase0.nbias) v(outn0) v(outp0) v(xcase0.p_bias) v(xcase0.rc_ct) v(xcase0.rc_gate) v(xcase0.rc_mid) v(rctrl0) v(xcase0.s1) v(xcase0.s2) v(vdd0) i(vsupply81) v(xcase81.att_n0) v(xcase81.att_n1) v(xcase81.att_n2) v(xcase81.att_p0) v(xcase81.att_p1) v(xcase81.att_p2) v(cctrl81) v(cm81) v(xcase81.inn) v(xcase81.inp) v(inx81) v(iny81) v(xcase81.nbias) v(outn81) v(outp81) v(xcase81.p_bias) v(rctrl81) v(xcase81.s1) v(xcase81.s2) v(vdd81)
ac dec 50 1meg 100g
wrdata ac_134.txt v(outp0) v(outn0) v(vid0) v(outp81) v(outn81) v(vid81)
alter Vr0 1.278
alter Vc0 0.243
op
wrdata op_135.txt i(vsupply0) v(xcase0.att_n0) v(xcase0.att_n1) v(xcase0.att_n2) v(xcase0.att_p0) v(xcase0.att_p1) v(xcase0.att_p2) v(cctrl0) v(cm0) v(xcase0.inn) v(xcase0.inp) v(inx0) v(iny0) v(xcase0.nbias) v(outn0) v(outp0) v(xcase0.p_bias) v(xcase0.rc_ct) v(xcase0.rc_gate) v(xcase0.rc_mid) v(rctrl0) v(xcase0.s1) v(xcase0.s2) v(vdd0) i(vsupply81) v(xcase81.att_n0) v(xcase81.att_n1) v(xcase81.att_n2) v(xcase81.att_p0) v(xcase81.att_p1) v(xcase81.att_p2) v(cctrl81) v(cm81) v(xcase81.inn) v(xcase81.inp) v(inx81) v(iny81) v(xcase81.nbias) v(outn81) v(outp81) v(xcase81.p_bias) v(rctrl81) v(xcase81.s1) v(xcase81.s2) v(vdd81)
ac dec 50 1meg 100g
wrdata ac_135.txt v(outp0) v(outn0) v(vid0) v(outp81) v(outn81) v(vid81)
alter Vr0 1.278
alter Vc0 0.27
op
wrdata op_136.txt i(vsupply0) v(xcase0.att_n0) v(xcase0.att_n1) v(xcase0.att_n2) v(xcase0.att_p0) v(xcase0.att_p1) v(xcase0.att_p2) v(cctrl0) v(cm0) v(xcase0.inn) v(xcase0.inp) v(inx0) v(iny0) v(xcase0.nbias) v(outn0) v(outp0) v(xcase0.p_bias) v(xcase0.rc_ct) v(xcase0.rc_gate) v(xcase0.rc_mid) v(rctrl0) v(xcase0.s1) v(xcase0.s2) v(vdd0) i(vsupply81) v(xcase81.att_n0) v(xcase81.att_n1) v(xcase81.att_n2) v(xcase81.att_p0) v(xcase81.att_p1) v(xcase81.att_p2) v(cctrl81) v(cm81) v(xcase81.inn) v(xcase81.inp) v(inx81) v(iny81) v(xcase81.nbias) v(outn81) v(outp81) v(xcase81.p_bias) v(rctrl81) v(xcase81.s1) v(xcase81.s2) v(vdd81)
ac dec 50 1meg 100g
wrdata ac_136.txt v(outp0) v(outn0) v(vid0) v(outp81) v(outn81) v(vid81)
alter Vr0 1.278
alter Vc0 0.297
op
wrdata op_137.txt i(vsupply0) v(xcase0.att_n0) v(xcase0.att_n1) v(xcase0.att_n2) v(xcase0.att_p0) v(xcase0.att_p1) v(xcase0.att_p2) v(cctrl0) v(cm0) v(xcase0.inn) v(xcase0.inp) v(inx0) v(iny0) v(xcase0.nbias) v(outn0) v(outp0) v(xcase0.p_bias) v(xcase0.rc_ct) v(xcase0.rc_gate) v(xcase0.rc_mid) v(rctrl0) v(xcase0.s1) v(xcase0.s2) v(vdd0) i(vsupply81) v(xcase81.att_n0) v(xcase81.att_n1) v(xcase81.att_n2) v(xcase81.att_p0) v(xcase81.att_p1) v(xcase81.att_p2) v(cctrl81) v(cm81) v(xcase81.inn) v(xcase81.inp) v(inx81) v(iny81) v(xcase81.nbias) v(outn81) v(outp81) v(xcase81.p_bias) v(rctrl81) v(xcase81.s1) v(xcase81.s2) v(vdd81)
ac dec 50 1meg 100g
wrdata ac_137.txt v(outp0) v(outn0) v(vid0) v(outp81) v(outn81) v(vid81)
alter Vr0 1.278
alter Vc0 0.324
op
wrdata op_138.txt i(vsupply0) v(xcase0.att_n0) v(xcase0.att_n1) v(xcase0.att_n2) v(xcase0.att_p0) v(xcase0.att_p1) v(xcase0.att_p2) v(cctrl0) v(cm0) v(xcase0.inn) v(xcase0.inp) v(inx0) v(iny0) v(xcase0.nbias) v(outn0) v(outp0) v(xcase0.p_bias) v(xcase0.rc_ct) v(xcase0.rc_gate) v(xcase0.rc_mid) v(rctrl0) v(xcase0.s1) v(xcase0.s2) v(vdd0) i(vsupply81) v(xcase81.att_n0) v(xcase81.att_n1) v(xcase81.att_n2) v(xcase81.att_p0) v(xcase81.att_p1) v(xcase81.att_p2) v(cctrl81) v(cm81) v(xcase81.inn) v(xcase81.inp) v(inx81) v(iny81) v(xcase81.nbias) v(outn81) v(outp81) v(xcase81.p_bias) v(rctrl81) v(xcase81.s1) v(xcase81.s2) v(vdd81)
ac dec 50 1meg 100g
wrdata ac_138.txt v(outp0) v(outn0) v(vid0) v(outp81) v(outn81) v(vid81)
alter Vr0 1.278
alter Vc0 0.351
op
wrdata op_139.txt i(vsupply0) v(xcase0.att_n0) v(xcase0.att_n1) v(xcase0.att_n2) v(xcase0.att_p0) v(xcase0.att_p1) v(xcase0.att_p2) v(cctrl0) v(cm0) v(xcase0.inn) v(xcase0.inp) v(inx0) v(iny0) v(xcase0.nbias) v(outn0) v(outp0) v(xcase0.p_bias) v(xcase0.rc_ct) v(xcase0.rc_gate) v(xcase0.rc_mid) v(rctrl0) v(xcase0.s1) v(xcase0.s2) v(vdd0) i(vsupply81) v(xcase81.att_n0) v(xcase81.att_n1) v(xcase81.att_n2) v(xcase81.att_p0) v(xcase81.att_p1) v(xcase81.att_p2) v(cctrl81) v(cm81) v(xcase81.inn) v(xcase81.inp) v(inx81) v(iny81) v(xcase81.nbias) v(outn81) v(outp81) v(xcase81.p_bias) v(rctrl81) v(xcase81.s1) v(xcase81.s2) v(vdd81)
ac dec 50 1meg 100g
wrdata ac_139.txt v(outp0) v(outn0) v(vid0) v(outp81) v(outn81) v(vid81)
alter Vr0 1.278
alter Vc0 0.378
op
wrdata op_140.txt i(vsupply0) v(xcase0.att_n0) v(xcase0.att_n1) v(xcase0.att_n2) v(xcase0.att_p0) v(xcase0.att_p1) v(xcase0.att_p2) v(cctrl0) v(cm0) v(xcase0.inn) v(xcase0.inp) v(inx0) v(iny0) v(xcase0.nbias) v(outn0) v(outp0) v(xcase0.p_bias) v(xcase0.rc_ct) v(xcase0.rc_gate) v(xcase0.rc_mid) v(rctrl0) v(xcase0.s1) v(xcase0.s2) v(vdd0) i(vsupply81) v(xcase81.att_n0) v(xcase81.att_n1) v(xcase81.att_n2) v(xcase81.att_p0) v(xcase81.att_p1) v(xcase81.att_p2) v(cctrl81) v(cm81) v(xcase81.inn) v(xcase81.inp) v(inx81) v(iny81) v(xcase81.nbias) v(outn81) v(outp81) v(xcase81.p_bias) v(rctrl81) v(xcase81.s1) v(xcase81.s2) v(vdd81)
ac dec 50 1meg 100g
wrdata ac_140.txt v(outp0) v(outn0) v(vid0) v(outp81) v(outn81) v(vid81)
alter Vr0 1.278
alter Vc0 0.405
op
wrdata op_141.txt i(vsupply0) v(xcase0.att_n0) v(xcase0.att_n1) v(xcase0.att_n2) v(xcase0.att_p0) v(xcase0.att_p1) v(xcase0.att_p2) v(cctrl0) v(cm0) v(xcase0.inn) v(xcase0.inp) v(inx0) v(iny0) v(xcase0.nbias) v(outn0) v(outp0) v(xcase0.p_bias) v(xcase0.rc_ct) v(xcase0.rc_gate) v(xcase0.rc_mid) v(rctrl0) v(xcase0.s1) v(xcase0.s2) v(vdd0) i(vsupply81) v(xcase81.att_n0) v(xcase81.att_n1) v(xcase81.att_n2) v(xcase81.att_p0) v(xcase81.att_p1) v(xcase81.att_p2) v(cctrl81) v(cm81) v(xcase81.inn) v(xcase81.inp) v(inx81) v(iny81) v(xcase81.nbias) v(outn81) v(outp81) v(xcase81.p_bias) v(rctrl81) v(xcase81.s1) v(xcase81.s2) v(vdd81)
ac dec 50 1meg 100g
wrdata ac_141.txt v(outp0) v(outn0) v(vid0) v(outp81) v(outn81) v(vid81)
alter Vr0 1.278
alter Vc0 0.432
op
wrdata op_142.txt i(vsupply0) v(xcase0.att_n0) v(xcase0.att_n1) v(xcase0.att_n2) v(xcase0.att_p0) v(xcase0.att_p1) v(xcase0.att_p2) v(cctrl0) v(cm0) v(xcase0.inn) v(xcase0.inp) v(inx0) v(iny0) v(xcase0.nbias) v(outn0) v(outp0) v(xcase0.p_bias) v(xcase0.rc_ct) v(xcase0.rc_gate) v(xcase0.rc_mid) v(rctrl0) v(xcase0.s1) v(xcase0.s2) v(vdd0) i(vsupply81) v(xcase81.att_n0) v(xcase81.att_n1) v(xcase81.att_n2) v(xcase81.att_p0) v(xcase81.att_p1) v(xcase81.att_p2) v(cctrl81) v(cm81) v(xcase81.inn) v(xcase81.inp) v(inx81) v(iny81) v(xcase81.nbias) v(outn81) v(outp81) v(xcase81.p_bias) v(rctrl81) v(xcase81.s1) v(xcase81.s2) v(vdd81)
ac dec 50 1meg 100g
wrdata ac_142.txt v(outp0) v(outn0) v(vid0) v(outp81) v(outn81) v(vid81)
alter Vr0 1.278
alter Vc0 0.459
op
wrdata op_143.txt i(vsupply0) v(xcase0.att_n0) v(xcase0.att_n1) v(xcase0.att_n2) v(xcase0.att_p0) v(xcase0.att_p1) v(xcase0.att_p2) v(cctrl0) v(cm0) v(xcase0.inn) v(xcase0.inp) v(inx0) v(iny0) v(xcase0.nbias) v(outn0) v(outp0) v(xcase0.p_bias) v(xcase0.rc_ct) v(xcase0.rc_gate) v(xcase0.rc_mid) v(rctrl0) v(xcase0.s1) v(xcase0.s2) v(vdd0) i(vsupply81) v(xcase81.att_n0) v(xcase81.att_n1) v(xcase81.att_n2) v(xcase81.att_p0) v(xcase81.att_p1) v(xcase81.att_p2) v(cctrl81) v(cm81) v(xcase81.inn) v(xcase81.inp) v(inx81) v(iny81) v(xcase81.nbias) v(outn81) v(outp81) v(xcase81.p_bias) v(rctrl81) v(xcase81.s1) v(xcase81.s2) v(vdd81)
ac dec 50 1meg 100g
wrdata ac_143.txt v(outp0) v(outn0) v(vid0) v(outp81) v(outn81) v(vid81)
alter Vr0 1.278
alter Vc0 0.486
op
wrdata op_144.txt i(vsupply0) v(xcase0.att_n0) v(xcase0.att_n1) v(xcase0.att_n2) v(xcase0.att_p0) v(xcase0.att_p1) v(xcase0.att_p2) v(cctrl0) v(cm0) v(xcase0.inn) v(xcase0.inp) v(inx0) v(iny0) v(xcase0.nbias) v(outn0) v(outp0) v(xcase0.p_bias) v(xcase0.rc_ct) v(xcase0.rc_gate) v(xcase0.rc_mid) v(rctrl0) v(xcase0.s1) v(xcase0.s2) v(vdd0) i(vsupply81) v(xcase81.att_n0) v(xcase81.att_n1) v(xcase81.att_n2) v(xcase81.att_p0) v(xcase81.att_p1) v(xcase81.att_p2) v(cctrl81) v(cm81) v(xcase81.inn) v(xcase81.inp) v(inx81) v(iny81) v(xcase81.nbias) v(outn81) v(outp81) v(xcase81.p_bias) v(rctrl81) v(xcase81.s1) v(xcase81.s2) v(vdd81)
ac dec 50 1meg 100g
wrdata ac_144.txt v(outp0) v(outn0) v(vid0) v(outp81) v(outn81) v(vid81)
alter Vr0 1.278
alter Vc0 0.513
op
wrdata op_145.txt i(vsupply0) v(xcase0.att_n0) v(xcase0.att_n1) v(xcase0.att_n2) v(xcase0.att_p0) v(xcase0.att_p1) v(xcase0.att_p2) v(cctrl0) v(cm0) v(xcase0.inn) v(xcase0.inp) v(inx0) v(iny0) v(xcase0.nbias) v(outn0) v(outp0) v(xcase0.p_bias) v(xcase0.rc_ct) v(xcase0.rc_gate) v(xcase0.rc_mid) v(rctrl0) v(xcase0.s1) v(xcase0.s2) v(vdd0) i(vsupply81) v(xcase81.att_n0) v(xcase81.att_n1) v(xcase81.att_n2) v(xcase81.att_p0) v(xcase81.att_p1) v(xcase81.att_p2) v(cctrl81) v(cm81) v(xcase81.inn) v(xcase81.inp) v(inx81) v(iny81) v(xcase81.nbias) v(outn81) v(outp81) v(xcase81.p_bias) v(rctrl81) v(xcase81.s1) v(xcase81.s2) v(vdd81)
ac dec 50 1meg 100g
wrdata ac_145.txt v(outp0) v(outn0) v(vid0) v(outp81) v(outn81) v(vid81)
alter Vr0 1.278
alter Vc0 0.54
op
wrdata op_146.txt i(vsupply0) v(xcase0.att_n0) v(xcase0.att_n1) v(xcase0.att_n2) v(xcase0.att_p0) v(xcase0.att_p1) v(xcase0.att_p2) v(cctrl0) v(cm0) v(xcase0.inn) v(xcase0.inp) v(inx0) v(iny0) v(xcase0.nbias) v(outn0) v(outp0) v(xcase0.p_bias) v(xcase0.rc_ct) v(xcase0.rc_gate) v(xcase0.rc_mid) v(rctrl0) v(xcase0.s1) v(xcase0.s2) v(vdd0) i(vsupply81) v(xcase81.att_n0) v(xcase81.att_n1) v(xcase81.att_n2) v(xcase81.att_p0) v(xcase81.att_p1) v(xcase81.att_p2) v(cctrl81) v(cm81) v(xcase81.inn) v(xcase81.inp) v(inx81) v(iny81) v(xcase81.nbias) v(outn81) v(outp81) v(xcase81.p_bias) v(rctrl81) v(xcase81.s1) v(xcase81.s2) v(vdd81)
ac dec 50 1meg 100g
wrdata ac_146.txt v(outp0) v(outn0) v(vid0) v(outp81) v(outn81) v(vid81)
alter Vr0 1.296
alter Vc0 0
op
wrdata op_147.txt i(vsupply0) v(xcase0.att_n0) v(xcase0.att_n1) v(xcase0.att_n2) v(xcase0.att_p0) v(xcase0.att_p1) v(xcase0.att_p2) v(cctrl0) v(cm0) v(xcase0.inn) v(xcase0.inp) v(inx0) v(iny0) v(xcase0.nbias) v(outn0) v(outp0) v(xcase0.p_bias) v(xcase0.rc_ct) v(xcase0.rc_gate) v(xcase0.rc_mid) v(rctrl0) v(xcase0.s1) v(xcase0.s2) v(vdd0) i(vsupply81) v(xcase81.att_n0) v(xcase81.att_n1) v(xcase81.att_n2) v(xcase81.att_p0) v(xcase81.att_p1) v(xcase81.att_p2) v(cctrl81) v(cm81) v(xcase81.inn) v(xcase81.inp) v(inx81) v(iny81) v(xcase81.nbias) v(outn81) v(outp81) v(xcase81.p_bias) v(rctrl81) v(xcase81.s1) v(xcase81.s2) v(vdd81)
ac dec 50 1meg 100g
wrdata ac_147.txt v(outp0) v(outn0) v(vid0) v(outp81) v(outn81) v(vid81)
alter Vr0 1.296
alter Vc0 0.027
op
wrdata op_148.txt i(vsupply0) v(xcase0.att_n0) v(xcase0.att_n1) v(xcase0.att_n2) v(xcase0.att_p0) v(xcase0.att_p1) v(xcase0.att_p2) v(cctrl0) v(cm0) v(xcase0.inn) v(xcase0.inp) v(inx0) v(iny0) v(xcase0.nbias) v(outn0) v(outp0) v(xcase0.p_bias) v(xcase0.rc_ct) v(xcase0.rc_gate) v(xcase0.rc_mid) v(rctrl0) v(xcase0.s1) v(xcase0.s2) v(vdd0) i(vsupply81) v(xcase81.att_n0) v(xcase81.att_n1) v(xcase81.att_n2) v(xcase81.att_p0) v(xcase81.att_p1) v(xcase81.att_p2) v(cctrl81) v(cm81) v(xcase81.inn) v(xcase81.inp) v(inx81) v(iny81) v(xcase81.nbias) v(outn81) v(outp81) v(xcase81.p_bias) v(rctrl81) v(xcase81.s1) v(xcase81.s2) v(vdd81)
ac dec 50 1meg 100g
wrdata ac_148.txt v(outp0) v(outn0) v(vid0) v(outp81) v(outn81) v(vid81)
alter Vr0 1.296
alter Vc0 0.054
op
wrdata op_149.txt i(vsupply0) v(xcase0.att_n0) v(xcase0.att_n1) v(xcase0.att_n2) v(xcase0.att_p0) v(xcase0.att_p1) v(xcase0.att_p2) v(cctrl0) v(cm0) v(xcase0.inn) v(xcase0.inp) v(inx0) v(iny0) v(xcase0.nbias) v(outn0) v(outp0) v(xcase0.p_bias) v(xcase0.rc_ct) v(xcase0.rc_gate) v(xcase0.rc_mid) v(rctrl0) v(xcase0.s1) v(xcase0.s2) v(vdd0) i(vsupply81) v(xcase81.att_n0) v(xcase81.att_n1) v(xcase81.att_n2) v(xcase81.att_p0) v(xcase81.att_p1) v(xcase81.att_p2) v(cctrl81) v(cm81) v(xcase81.inn) v(xcase81.inp) v(inx81) v(iny81) v(xcase81.nbias) v(outn81) v(outp81) v(xcase81.p_bias) v(rctrl81) v(xcase81.s1) v(xcase81.s2) v(vdd81)
ac dec 50 1meg 100g
wrdata ac_149.txt v(outp0) v(outn0) v(vid0) v(outp81) v(outn81) v(vid81)
alter Vr0 1.296
alter Vc0 0.081
op
wrdata op_150.txt i(vsupply0) v(xcase0.att_n0) v(xcase0.att_n1) v(xcase0.att_n2) v(xcase0.att_p0) v(xcase0.att_p1) v(xcase0.att_p2) v(cctrl0) v(cm0) v(xcase0.inn) v(xcase0.inp) v(inx0) v(iny0) v(xcase0.nbias) v(outn0) v(outp0) v(xcase0.p_bias) v(xcase0.rc_ct) v(xcase0.rc_gate) v(xcase0.rc_mid) v(rctrl0) v(xcase0.s1) v(xcase0.s2) v(vdd0) i(vsupply81) v(xcase81.att_n0) v(xcase81.att_n1) v(xcase81.att_n2) v(xcase81.att_p0) v(xcase81.att_p1) v(xcase81.att_p2) v(cctrl81) v(cm81) v(xcase81.inn) v(xcase81.inp) v(inx81) v(iny81) v(xcase81.nbias) v(outn81) v(outp81) v(xcase81.p_bias) v(rctrl81) v(xcase81.s1) v(xcase81.s2) v(vdd81)
ac dec 50 1meg 100g
wrdata ac_150.txt v(outp0) v(outn0) v(vid0) v(outp81) v(outn81) v(vid81)
alter Vr0 1.296
alter Vc0 0.108
op
wrdata op_151.txt i(vsupply0) v(xcase0.att_n0) v(xcase0.att_n1) v(xcase0.att_n2) v(xcase0.att_p0) v(xcase0.att_p1) v(xcase0.att_p2) v(cctrl0) v(cm0) v(xcase0.inn) v(xcase0.inp) v(inx0) v(iny0) v(xcase0.nbias) v(outn0) v(outp0) v(xcase0.p_bias) v(xcase0.rc_ct) v(xcase0.rc_gate) v(xcase0.rc_mid) v(rctrl0) v(xcase0.s1) v(xcase0.s2) v(vdd0) i(vsupply81) v(xcase81.att_n0) v(xcase81.att_n1) v(xcase81.att_n2) v(xcase81.att_p0) v(xcase81.att_p1) v(xcase81.att_p2) v(cctrl81) v(cm81) v(xcase81.inn) v(xcase81.inp) v(inx81) v(iny81) v(xcase81.nbias) v(outn81) v(outp81) v(xcase81.p_bias) v(rctrl81) v(xcase81.s1) v(xcase81.s2) v(vdd81)
ac dec 50 1meg 100g
wrdata ac_151.txt v(outp0) v(outn0) v(vid0) v(outp81) v(outn81) v(vid81)
alter Vr0 1.296
alter Vc0 0.135
op
wrdata op_152.txt i(vsupply0) v(xcase0.att_n0) v(xcase0.att_n1) v(xcase0.att_n2) v(xcase0.att_p0) v(xcase0.att_p1) v(xcase0.att_p2) v(cctrl0) v(cm0) v(xcase0.inn) v(xcase0.inp) v(inx0) v(iny0) v(xcase0.nbias) v(outn0) v(outp0) v(xcase0.p_bias) v(xcase0.rc_ct) v(xcase0.rc_gate) v(xcase0.rc_mid) v(rctrl0) v(xcase0.s1) v(xcase0.s2) v(vdd0) i(vsupply81) v(xcase81.att_n0) v(xcase81.att_n1) v(xcase81.att_n2) v(xcase81.att_p0) v(xcase81.att_p1) v(xcase81.att_p2) v(cctrl81) v(cm81) v(xcase81.inn) v(xcase81.inp) v(inx81) v(iny81) v(xcase81.nbias) v(outn81) v(outp81) v(xcase81.p_bias) v(rctrl81) v(xcase81.s1) v(xcase81.s2) v(vdd81)
ac dec 50 1meg 100g
wrdata ac_152.txt v(outp0) v(outn0) v(vid0) v(outp81) v(outn81) v(vid81)
alter Vr0 1.296
alter Vc0 0.162
op
wrdata op_153.txt i(vsupply0) v(xcase0.att_n0) v(xcase0.att_n1) v(xcase0.att_n2) v(xcase0.att_p0) v(xcase0.att_p1) v(xcase0.att_p2) v(cctrl0) v(cm0) v(xcase0.inn) v(xcase0.inp) v(inx0) v(iny0) v(xcase0.nbias) v(outn0) v(outp0) v(xcase0.p_bias) v(xcase0.rc_ct) v(xcase0.rc_gate) v(xcase0.rc_mid) v(rctrl0) v(xcase0.s1) v(xcase0.s2) v(vdd0) i(vsupply81) v(xcase81.att_n0) v(xcase81.att_n1) v(xcase81.att_n2) v(xcase81.att_p0) v(xcase81.att_p1) v(xcase81.att_p2) v(cctrl81) v(cm81) v(xcase81.inn) v(xcase81.inp) v(inx81) v(iny81) v(xcase81.nbias) v(outn81) v(outp81) v(xcase81.p_bias) v(rctrl81) v(xcase81.s1) v(xcase81.s2) v(vdd81)
ac dec 50 1meg 100g
wrdata ac_153.txt v(outp0) v(outn0) v(vid0) v(outp81) v(outn81) v(vid81)
alter Vr0 1.296
alter Vc0 0.189
op
wrdata op_154.txt i(vsupply0) v(xcase0.att_n0) v(xcase0.att_n1) v(xcase0.att_n2) v(xcase0.att_p0) v(xcase0.att_p1) v(xcase0.att_p2) v(cctrl0) v(cm0) v(xcase0.inn) v(xcase0.inp) v(inx0) v(iny0) v(xcase0.nbias) v(outn0) v(outp0) v(xcase0.p_bias) v(xcase0.rc_ct) v(xcase0.rc_gate) v(xcase0.rc_mid) v(rctrl0) v(xcase0.s1) v(xcase0.s2) v(vdd0) i(vsupply81) v(xcase81.att_n0) v(xcase81.att_n1) v(xcase81.att_n2) v(xcase81.att_p0) v(xcase81.att_p1) v(xcase81.att_p2) v(cctrl81) v(cm81) v(xcase81.inn) v(xcase81.inp) v(inx81) v(iny81) v(xcase81.nbias) v(outn81) v(outp81) v(xcase81.p_bias) v(rctrl81) v(xcase81.s1) v(xcase81.s2) v(vdd81)
ac dec 50 1meg 100g
wrdata ac_154.txt v(outp0) v(outn0) v(vid0) v(outp81) v(outn81) v(vid81)
alter Vr0 1.296
alter Vc0 0.216
op
wrdata op_155.txt i(vsupply0) v(xcase0.att_n0) v(xcase0.att_n1) v(xcase0.att_n2) v(xcase0.att_p0) v(xcase0.att_p1) v(xcase0.att_p2) v(cctrl0) v(cm0) v(xcase0.inn) v(xcase0.inp) v(inx0) v(iny0) v(xcase0.nbias) v(outn0) v(outp0) v(xcase0.p_bias) v(xcase0.rc_ct) v(xcase0.rc_gate) v(xcase0.rc_mid) v(rctrl0) v(xcase0.s1) v(xcase0.s2) v(vdd0) i(vsupply81) v(xcase81.att_n0) v(xcase81.att_n1) v(xcase81.att_n2) v(xcase81.att_p0) v(xcase81.att_p1) v(xcase81.att_p2) v(cctrl81) v(cm81) v(xcase81.inn) v(xcase81.inp) v(inx81) v(iny81) v(xcase81.nbias) v(outn81) v(outp81) v(xcase81.p_bias) v(rctrl81) v(xcase81.s1) v(xcase81.s2) v(vdd81)
ac dec 50 1meg 100g
wrdata ac_155.txt v(outp0) v(outn0) v(vid0) v(outp81) v(outn81) v(vid81)
alter Vr0 1.296
alter Vc0 0.243
op
wrdata op_156.txt i(vsupply0) v(xcase0.att_n0) v(xcase0.att_n1) v(xcase0.att_n2) v(xcase0.att_p0) v(xcase0.att_p1) v(xcase0.att_p2) v(cctrl0) v(cm0) v(xcase0.inn) v(xcase0.inp) v(inx0) v(iny0) v(xcase0.nbias) v(outn0) v(outp0) v(xcase0.p_bias) v(xcase0.rc_ct) v(xcase0.rc_gate) v(xcase0.rc_mid) v(rctrl0) v(xcase0.s1) v(xcase0.s2) v(vdd0) i(vsupply81) v(xcase81.att_n0) v(xcase81.att_n1) v(xcase81.att_n2) v(xcase81.att_p0) v(xcase81.att_p1) v(xcase81.att_p2) v(cctrl81) v(cm81) v(xcase81.inn) v(xcase81.inp) v(inx81) v(iny81) v(xcase81.nbias) v(outn81) v(outp81) v(xcase81.p_bias) v(rctrl81) v(xcase81.s1) v(xcase81.s2) v(vdd81)
ac dec 50 1meg 100g
wrdata ac_156.txt v(outp0) v(outn0) v(vid0) v(outp81) v(outn81) v(vid81)
alter Vr0 1.296
alter Vc0 0.27
op
wrdata op_157.txt i(vsupply0) v(xcase0.att_n0) v(xcase0.att_n1) v(xcase0.att_n2) v(xcase0.att_p0) v(xcase0.att_p1) v(xcase0.att_p2) v(cctrl0) v(cm0) v(xcase0.inn) v(xcase0.inp) v(inx0) v(iny0) v(xcase0.nbias) v(outn0) v(outp0) v(xcase0.p_bias) v(xcase0.rc_ct) v(xcase0.rc_gate) v(xcase0.rc_mid) v(rctrl0) v(xcase0.s1) v(xcase0.s2) v(vdd0) i(vsupply81) v(xcase81.att_n0) v(xcase81.att_n1) v(xcase81.att_n2) v(xcase81.att_p0) v(xcase81.att_p1) v(xcase81.att_p2) v(cctrl81) v(cm81) v(xcase81.inn) v(xcase81.inp) v(inx81) v(iny81) v(xcase81.nbias) v(outn81) v(outp81) v(xcase81.p_bias) v(rctrl81) v(xcase81.s1) v(xcase81.s2) v(vdd81)
ac dec 50 1meg 100g
wrdata ac_157.txt v(outp0) v(outn0) v(vid0) v(outp81) v(outn81) v(vid81)
alter Vr0 1.296
alter Vc0 0.297
op
wrdata op_158.txt i(vsupply0) v(xcase0.att_n0) v(xcase0.att_n1) v(xcase0.att_n2) v(xcase0.att_p0) v(xcase0.att_p1) v(xcase0.att_p2) v(cctrl0) v(cm0) v(xcase0.inn) v(xcase0.inp) v(inx0) v(iny0) v(xcase0.nbias) v(outn0) v(outp0) v(xcase0.p_bias) v(xcase0.rc_ct) v(xcase0.rc_gate) v(xcase0.rc_mid) v(rctrl0) v(xcase0.s1) v(xcase0.s2) v(vdd0) i(vsupply81) v(xcase81.att_n0) v(xcase81.att_n1) v(xcase81.att_n2) v(xcase81.att_p0) v(xcase81.att_p1) v(xcase81.att_p2) v(cctrl81) v(cm81) v(xcase81.inn) v(xcase81.inp) v(inx81) v(iny81) v(xcase81.nbias) v(outn81) v(outp81) v(xcase81.p_bias) v(rctrl81) v(xcase81.s1) v(xcase81.s2) v(vdd81)
ac dec 50 1meg 100g
wrdata ac_158.txt v(outp0) v(outn0) v(vid0) v(outp81) v(outn81) v(vid81)
alter Vr0 1.296
alter Vc0 0.324
op
wrdata op_159.txt i(vsupply0) v(xcase0.att_n0) v(xcase0.att_n1) v(xcase0.att_n2) v(xcase0.att_p0) v(xcase0.att_p1) v(xcase0.att_p2) v(cctrl0) v(cm0) v(xcase0.inn) v(xcase0.inp) v(inx0) v(iny0) v(xcase0.nbias) v(outn0) v(outp0) v(xcase0.p_bias) v(xcase0.rc_ct) v(xcase0.rc_gate) v(xcase0.rc_mid) v(rctrl0) v(xcase0.s1) v(xcase0.s2) v(vdd0) i(vsupply81) v(xcase81.att_n0) v(xcase81.att_n1) v(xcase81.att_n2) v(xcase81.att_p0) v(xcase81.att_p1) v(xcase81.att_p2) v(cctrl81) v(cm81) v(xcase81.inn) v(xcase81.inp) v(inx81) v(iny81) v(xcase81.nbias) v(outn81) v(outp81) v(xcase81.p_bias) v(rctrl81) v(xcase81.s1) v(xcase81.s2) v(vdd81)
ac dec 50 1meg 100g
wrdata ac_159.txt v(outp0) v(outn0) v(vid0) v(outp81) v(outn81) v(vid81)
alter Vr0 1.296
alter Vc0 0.351
op
wrdata op_160.txt i(vsupply0) v(xcase0.att_n0) v(xcase0.att_n1) v(xcase0.att_n2) v(xcase0.att_p0) v(xcase0.att_p1) v(xcase0.att_p2) v(cctrl0) v(cm0) v(xcase0.inn) v(xcase0.inp) v(inx0) v(iny0) v(xcase0.nbias) v(outn0) v(outp0) v(xcase0.p_bias) v(xcase0.rc_ct) v(xcase0.rc_gate) v(xcase0.rc_mid) v(rctrl0) v(xcase0.s1) v(xcase0.s2) v(vdd0) i(vsupply81) v(xcase81.att_n0) v(xcase81.att_n1) v(xcase81.att_n2) v(xcase81.att_p0) v(xcase81.att_p1) v(xcase81.att_p2) v(cctrl81) v(cm81) v(xcase81.inn) v(xcase81.inp) v(inx81) v(iny81) v(xcase81.nbias) v(outn81) v(outp81) v(xcase81.p_bias) v(rctrl81) v(xcase81.s1) v(xcase81.s2) v(vdd81)
ac dec 50 1meg 100g
wrdata ac_160.txt v(outp0) v(outn0) v(vid0) v(outp81) v(outn81) v(vid81)
alter Vr0 1.296
alter Vc0 0.378
op
wrdata op_161.txt i(vsupply0) v(xcase0.att_n0) v(xcase0.att_n1) v(xcase0.att_n2) v(xcase0.att_p0) v(xcase0.att_p1) v(xcase0.att_p2) v(cctrl0) v(cm0) v(xcase0.inn) v(xcase0.inp) v(inx0) v(iny0) v(xcase0.nbias) v(outn0) v(outp0) v(xcase0.p_bias) v(xcase0.rc_ct) v(xcase0.rc_gate) v(xcase0.rc_mid) v(rctrl0) v(xcase0.s1) v(xcase0.s2) v(vdd0) i(vsupply81) v(xcase81.att_n0) v(xcase81.att_n1) v(xcase81.att_n2) v(xcase81.att_p0) v(xcase81.att_p1) v(xcase81.att_p2) v(cctrl81) v(cm81) v(xcase81.inn) v(xcase81.inp) v(inx81) v(iny81) v(xcase81.nbias) v(outn81) v(outp81) v(xcase81.p_bias) v(rctrl81) v(xcase81.s1) v(xcase81.s2) v(vdd81)
ac dec 50 1meg 100g
wrdata ac_161.txt v(outp0) v(outn0) v(vid0) v(outp81) v(outn81) v(vid81)
alter Vr0 1.296
alter Vc0 0.405
op
wrdata op_162.txt i(vsupply0) v(xcase0.att_n0) v(xcase0.att_n1) v(xcase0.att_n2) v(xcase0.att_p0) v(xcase0.att_p1) v(xcase0.att_p2) v(cctrl0) v(cm0) v(xcase0.inn) v(xcase0.inp) v(inx0) v(iny0) v(xcase0.nbias) v(outn0) v(outp0) v(xcase0.p_bias) v(xcase0.rc_ct) v(xcase0.rc_gate) v(xcase0.rc_mid) v(rctrl0) v(xcase0.s1) v(xcase0.s2) v(vdd0) i(vsupply81) v(xcase81.att_n0) v(xcase81.att_n1) v(xcase81.att_n2) v(xcase81.att_p0) v(xcase81.att_p1) v(xcase81.att_p2) v(cctrl81) v(cm81) v(xcase81.inn) v(xcase81.inp) v(inx81) v(iny81) v(xcase81.nbias) v(outn81) v(outp81) v(xcase81.p_bias) v(rctrl81) v(xcase81.s1) v(xcase81.s2) v(vdd81)
ac dec 50 1meg 100g
wrdata ac_162.txt v(outp0) v(outn0) v(vid0) v(outp81) v(outn81) v(vid81)
alter Vr0 1.296
alter Vc0 0.432
op
wrdata op_163.txt i(vsupply0) v(xcase0.att_n0) v(xcase0.att_n1) v(xcase0.att_n2) v(xcase0.att_p0) v(xcase0.att_p1) v(xcase0.att_p2) v(cctrl0) v(cm0) v(xcase0.inn) v(xcase0.inp) v(inx0) v(iny0) v(xcase0.nbias) v(outn0) v(outp0) v(xcase0.p_bias) v(xcase0.rc_ct) v(xcase0.rc_gate) v(xcase0.rc_mid) v(rctrl0) v(xcase0.s1) v(xcase0.s2) v(vdd0) i(vsupply81) v(xcase81.att_n0) v(xcase81.att_n1) v(xcase81.att_n2) v(xcase81.att_p0) v(xcase81.att_p1) v(xcase81.att_p2) v(cctrl81) v(cm81) v(xcase81.inn) v(xcase81.inp) v(inx81) v(iny81) v(xcase81.nbias) v(outn81) v(outp81) v(xcase81.p_bias) v(rctrl81) v(xcase81.s1) v(xcase81.s2) v(vdd81)
ac dec 50 1meg 100g
wrdata ac_163.txt v(outp0) v(outn0) v(vid0) v(outp81) v(outn81) v(vid81)
alter Vr0 1.296
alter Vc0 0.459
op
wrdata op_164.txt i(vsupply0) v(xcase0.att_n0) v(xcase0.att_n1) v(xcase0.att_n2) v(xcase0.att_p0) v(xcase0.att_p1) v(xcase0.att_p2) v(cctrl0) v(cm0) v(xcase0.inn) v(xcase0.inp) v(inx0) v(iny0) v(xcase0.nbias) v(outn0) v(outp0) v(xcase0.p_bias) v(xcase0.rc_ct) v(xcase0.rc_gate) v(xcase0.rc_mid) v(rctrl0) v(xcase0.s1) v(xcase0.s2) v(vdd0) i(vsupply81) v(xcase81.att_n0) v(xcase81.att_n1) v(xcase81.att_n2) v(xcase81.att_p0) v(xcase81.att_p1) v(xcase81.att_p2) v(cctrl81) v(cm81) v(xcase81.inn) v(xcase81.inp) v(inx81) v(iny81) v(xcase81.nbias) v(outn81) v(outp81) v(xcase81.p_bias) v(rctrl81) v(xcase81.s1) v(xcase81.s2) v(vdd81)
ac dec 50 1meg 100g
wrdata ac_164.txt v(outp0) v(outn0) v(vid0) v(outp81) v(outn81) v(vid81)
alter Vr0 1.296
alter Vc0 0.486
op
wrdata op_165.txt i(vsupply0) v(xcase0.att_n0) v(xcase0.att_n1) v(xcase0.att_n2) v(xcase0.att_p0) v(xcase0.att_p1) v(xcase0.att_p2) v(cctrl0) v(cm0) v(xcase0.inn) v(xcase0.inp) v(inx0) v(iny0) v(xcase0.nbias) v(outn0) v(outp0) v(xcase0.p_bias) v(xcase0.rc_ct) v(xcase0.rc_gate) v(xcase0.rc_mid) v(rctrl0) v(xcase0.s1) v(xcase0.s2) v(vdd0) i(vsupply81) v(xcase81.att_n0) v(xcase81.att_n1) v(xcase81.att_n2) v(xcase81.att_p0) v(xcase81.att_p1) v(xcase81.att_p2) v(cctrl81) v(cm81) v(xcase81.inn) v(xcase81.inp) v(inx81) v(iny81) v(xcase81.nbias) v(outn81) v(outp81) v(xcase81.p_bias) v(rctrl81) v(xcase81.s1) v(xcase81.s2) v(vdd81)
ac dec 50 1meg 100g
wrdata ac_165.txt v(outp0) v(outn0) v(vid0) v(outp81) v(outn81) v(vid81)
alter Vr0 1.296
alter Vc0 0.513
op
wrdata op_166.txt i(vsupply0) v(xcase0.att_n0) v(xcase0.att_n1) v(xcase0.att_n2) v(xcase0.att_p0) v(xcase0.att_p1) v(xcase0.att_p2) v(cctrl0) v(cm0) v(xcase0.inn) v(xcase0.inp) v(inx0) v(iny0) v(xcase0.nbias) v(outn0) v(outp0) v(xcase0.p_bias) v(xcase0.rc_ct) v(xcase0.rc_gate) v(xcase0.rc_mid) v(rctrl0) v(xcase0.s1) v(xcase0.s2) v(vdd0) i(vsupply81) v(xcase81.att_n0) v(xcase81.att_n1) v(xcase81.att_n2) v(xcase81.att_p0) v(xcase81.att_p1) v(xcase81.att_p2) v(cctrl81) v(cm81) v(xcase81.inn) v(xcase81.inp) v(inx81) v(iny81) v(xcase81.nbias) v(outn81) v(outp81) v(xcase81.p_bias) v(rctrl81) v(xcase81.s1) v(xcase81.s2) v(vdd81)
ac dec 50 1meg 100g
wrdata ac_166.txt v(outp0) v(outn0) v(vid0) v(outp81) v(outn81) v(vid81)
alter Vr0 1.296
alter Vc0 0.54
op
wrdata op_167.txt i(vsupply0) v(xcase0.att_n0) v(xcase0.att_n1) v(xcase0.att_n2) v(xcase0.att_p0) v(xcase0.att_p1) v(xcase0.att_p2) v(cctrl0) v(cm0) v(xcase0.inn) v(xcase0.inp) v(inx0) v(iny0) v(xcase0.nbias) v(outn0) v(outp0) v(xcase0.p_bias) v(xcase0.rc_ct) v(xcase0.rc_gate) v(xcase0.rc_mid) v(rctrl0) v(xcase0.s1) v(xcase0.s2) v(vdd0) i(vsupply81) v(xcase81.att_n0) v(xcase81.att_n1) v(xcase81.att_n2) v(xcase81.att_p0) v(xcase81.att_p1) v(xcase81.att_p2) v(cctrl81) v(cm81) v(xcase81.inn) v(xcase81.inp) v(inx81) v(iny81) v(xcase81.nbias) v(outn81) v(outp81) v(xcase81.p_bias) v(rctrl81) v(xcase81.s1) v(xcase81.s2) v(vdd81)
ac dec 50 1meg 100g
wrdata ac_167.txt v(outp0) v(outn0) v(vid0) v(outp81) v(outn81) v(vid81)
alter Vr0 1.314
alter Vc0 0
op
wrdata op_168.txt i(vsupply0) v(xcase0.att_n0) v(xcase0.att_n1) v(xcase0.att_n2) v(xcase0.att_p0) v(xcase0.att_p1) v(xcase0.att_p2) v(cctrl0) v(cm0) v(xcase0.inn) v(xcase0.inp) v(inx0) v(iny0) v(xcase0.nbias) v(outn0) v(outp0) v(xcase0.p_bias) v(xcase0.rc_ct) v(xcase0.rc_gate) v(xcase0.rc_mid) v(rctrl0) v(xcase0.s1) v(xcase0.s2) v(vdd0) i(vsupply81) v(xcase81.att_n0) v(xcase81.att_n1) v(xcase81.att_n2) v(xcase81.att_p0) v(xcase81.att_p1) v(xcase81.att_p2) v(cctrl81) v(cm81) v(xcase81.inn) v(xcase81.inp) v(inx81) v(iny81) v(xcase81.nbias) v(outn81) v(outp81) v(xcase81.p_bias) v(rctrl81) v(xcase81.s1) v(xcase81.s2) v(vdd81)
ac dec 50 1meg 100g
wrdata ac_168.txt v(outp0) v(outn0) v(vid0) v(outp81) v(outn81) v(vid81)
alter Vr0 1.314
alter Vc0 0.027
op
wrdata op_169.txt i(vsupply0) v(xcase0.att_n0) v(xcase0.att_n1) v(xcase0.att_n2) v(xcase0.att_p0) v(xcase0.att_p1) v(xcase0.att_p2) v(cctrl0) v(cm0) v(xcase0.inn) v(xcase0.inp) v(inx0) v(iny0) v(xcase0.nbias) v(outn0) v(outp0) v(xcase0.p_bias) v(xcase0.rc_ct) v(xcase0.rc_gate) v(xcase0.rc_mid) v(rctrl0) v(xcase0.s1) v(xcase0.s2) v(vdd0) i(vsupply81) v(xcase81.att_n0) v(xcase81.att_n1) v(xcase81.att_n2) v(xcase81.att_p0) v(xcase81.att_p1) v(xcase81.att_p2) v(cctrl81) v(cm81) v(xcase81.inn) v(xcase81.inp) v(inx81) v(iny81) v(xcase81.nbias) v(outn81) v(outp81) v(xcase81.p_bias) v(rctrl81) v(xcase81.s1) v(xcase81.s2) v(vdd81)
ac dec 50 1meg 100g
wrdata ac_169.txt v(outp0) v(outn0) v(vid0) v(outp81) v(outn81) v(vid81)
alter Vr0 1.314
alter Vc0 0.054
op
wrdata op_170.txt i(vsupply0) v(xcase0.att_n0) v(xcase0.att_n1) v(xcase0.att_n2) v(xcase0.att_p0) v(xcase0.att_p1) v(xcase0.att_p2) v(cctrl0) v(cm0) v(xcase0.inn) v(xcase0.inp) v(inx0) v(iny0) v(xcase0.nbias) v(outn0) v(outp0) v(xcase0.p_bias) v(xcase0.rc_ct) v(xcase0.rc_gate) v(xcase0.rc_mid) v(rctrl0) v(xcase0.s1) v(xcase0.s2) v(vdd0) i(vsupply81) v(xcase81.att_n0) v(xcase81.att_n1) v(xcase81.att_n2) v(xcase81.att_p0) v(xcase81.att_p1) v(xcase81.att_p2) v(cctrl81) v(cm81) v(xcase81.inn) v(xcase81.inp) v(inx81) v(iny81) v(xcase81.nbias) v(outn81) v(outp81) v(xcase81.p_bias) v(rctrl81) v(xcase81.s1) v(xcase81.s2) v(vdd81)
ac dec 50 1meg 100g
wrdata ac_170.txt v(outp0) v(outn0) v(vid0) v(outp81) v(outn81) v(vid81)
alter Vr0 1.314
alter Vc0 0.081
op
wrdata op_171.txt i(vsupply0) v(xcase0.att_n0) v(xcase0.att_n1) v(xcase0.att_n2) v(xcase0.att_p0) v(xcase0.att_p1) v(xcase0.att_p2) v(cctrl0) v(cm0) v(xcase0.inn) v(xcase0.inp) v(inx0) v(iny0) v(xcase0.nbias) v(outn0) v(outp0) v(xcase0.p_bias) v(xcase0.rc_ct) v(xcase0.rc_gate) v(xcase0.rc_mid) v(rctrl0) v(xcase0.s1) v(xcase0.s2) v(vdd0) i(vsupply81) v(xcase81.att_n0) v(xcase81.att_n1) v(xcase81.att_n2) v(xcase81.att_p0) v(xcase81.att_p1) v(xcase81.att_p2) v(cctrl81) v(cm81) v(xcase81.inn) v(xcase81.inp) v(inx81) v(iny81) v(xcase81.nbias) v(outn81) v(outp81) v(xcase81.p_bias) v(rctrl81) v(xcase81.s1) v(xcase81.s2) v(vdd81)
ac dec 50 1meg 100g
wrdata ac_171.txt v(outp0) v(outn0) v(vid0) v(outp81) v(outn81) v(vid81)
alter Vr0 1.314
alter Vc0 0.108
op
wrdata op_172.txt i(vsupply0) v(xcase0.att_n0) v(xcase0.att_n1) v(xcase0.att_n2) v(xcase0.att_p0) v(xcase0.att_p1) v(xcase0.att_p2) v(cctrl0) v(cm0) v(xcase0.inn) v(xcase0.inp) v(inx0) v(iny0) v(xcase0.nbias) v(outn0) v(outp0) v(xcase0.p_bias) v(xcase0.rc_ct) v(xcase0.rc_gate) v(xcase0.rc_mid) v(rctrl0) v(xcase0.s1) v(xcase0.s2) v(vdd0) i(vsupply81) v(xcase81.att_n0) v(xcase81.att_n1) v(xcase81.att_n2) v(xcase81.att_p0) v(xcase81.att_p1) v(xcase81.att_p2) v(cctrl81) v(cm81) v(xcase81.inn) v(xcase81.inp) v(inx81) v(iny81) v(xcase81.nbias) v(outn81) v(outp81) v(xcase81.p_bias) v(rctrl81) v(xcase81.s1) v(xcase81.s2) v(vdd81)
ac dec 50 1meg 100g
wrdata ac_172.txt v(outp0) v(outn0) v(vid0) v(outp81) v(outn81) v(vid81)
alter Vr0 1.314
alter Vc0 0.135
op
wrdata op_173.txt i(vsupply0) v(xcase0.att_n0) v(xcase0.att_n1) v(xcase0.att_n2) v(xcase0.att_p0) v(xcase0.att_p1) v(xcase0.att_p2) v(cctrl0) v(cm0) v(xcase0.inn) v(xcase0.inp) v(inx0) v(iny0) v(xcase0.nbias) v(outn0) v(outp0) v(xcase0.p_bias) v(xcase0.rc_ct) v(xcase0.rc_gate) v(xcase0.rc_mid) v(rctrl0) v(xcase0.s1) v(xcase0.s2) v(vdd0) i(vsupply81) v(xcase81.att_n0) v(xcase81.att_n1) v(xcase81.att_n2) v(xcase81.att_p0) v(xcase81.att_p1) v(xcase81.att_p2) v(cctrl81) v(cm81) v(xcase81.inn) v(xcase81.inp) v(inx81) v(iny81) v(xcase81.nbias) v(outn81) v(outp81) v(xcase81.p_bias) v(rctrl81) v(xcase81.s1) v(xcase81.s2) v(vdd81)
ac dec 50 1meg 100g
wrdata ac_173.txt v(outp0) v(outn0) v(vid0) v(outp81) v(outn81) v(vid81)
alter Vr0 1.314
alter Vc0 0.162
op
wrdata op_174.txt i(vsupply0) v(xcase0.att_n0) v(xcase0.att_n1) v(xcase0.att_n2) v(xcase0.att_p0) v(xcase0.att_p1) v(xcase0.att_p2) v(cctrl0) v(cm0) v(xcase0.inn) v(xcase0.inp) v(inx0) v(iny0) v(xcase0.nbias) v(outn0) v(outp0) v(xcase0.p_bias) v(xcase0.rc_ct) v(xcase0.rc_gate) v(xcase0.rc_mid) v(rctrl0) v(xcase0.s1) v(xcase0.s2) v(vdd0) i(vsupply81) v(xcase81.att_n0) v(xcase81.att_n1) v(xcase81.att_n2) v(xcase81.att_p0) v(xcase81.att_p1) v(xcase81.att_p2) v(cctrl81) v(cm81) v(xcase81.inn) v(xcase81.inp) v(inx81) v(iny81) v(xcase81.nbias) v(outn81) v(outp81) v(xcase81.p_bias) v(rctrl81) v(xcase81.s1) v(xcase81.s2) v(vdd81)
ac dec 50 1meg 100g
wrdata ac_174.txt v(outp0) v(outn0) v(vid0) v(outp81) v(outn81) v(vid81)
alter Vr0 1.314
alter Vc0 0.189
op
wrdata op_175.txt i(vsupply0) v(xcase0.att_n0) v(xcase0.att_n1) v(xcase0.att_n2) v(xcase0.att_p0) v(xcase0.att_p1) v(xcase0.att_p2) v(cctrl0) v(cm0) v(xcase0.inn) v(xcase0.inp) v(inx0) v(iny0) v(xcase0.nbias) v(outn0) v(outp0) v(xcase0.p_bias) v(xcase0.rc_ct) v(xcase0.rc_gate) v(xcase0.rc_mid) v(rctrl0) v(xcase0.s1) v(xcase0.s2) v(vdd0) i(vsupply81) v(xcase81.att_n0) v(xcase81.att_n1) v(xcase81.att_n2) v(xcase81.att_p0) v(xcase81.att_p1) v(xcase81.att_p2) v(cctrl81) v(cm81) v(xcase81.inn) v(xcase81.inp) v(inx81) v(iny81) v(xcase81.nbias) v(outn81) v(outp81) v(xcase81.p_bias) v(rctrl81) v(xcase81.s1) v(xcase81.s2) v(vdd81)
ac dec 50 1meg 100g
wrdata ac_175.txt v(outp0) v(outn0) v(vid0) v(outp81) v(outn81) v(vid81)
alter Vr0 1.314
alter Vc0 0.216
op
wrdata op_176.txt i(vsupply0) v(xcase0.att_n0) v(xcase0.att_n1) v(xcase0.att_n2) v(xcase0.att_p0) v(xcase0.att_p1) v(xcase0.att_p2) v(cctrl0) v(cm0) v(xcase0.inn) v(xcase0.inp) v(inx0) v(iny0) v(xcase0.nbias) v(outn0) v(outp0) v(xcase0.p_bias) v(xcase0.rc_ct) v(xcase0.rc_gate) v(xcase0.rc_mid) v(rctrl0) v(xcase0.s1) v(xcase0.s2) v(vdd0) i(vsupply81) v(xcase81.att_n0) v(xcase81.att_n1) v(xcase81.att_n2) v(xcase81.att_p0) v(xcase81.att_p1) v(xcase81.att_p2) v(cctrl81) v(cm81) v(xcase81.inn) v(xcase81.inp) v(inx81) v(iny81) v(xcase81.nbias) v(outn81) v(outp81) v(xcase81.p_bias) v(rctrl81) v(xcase81.s1) v(xcase81.s2) v(vdd81)
ac dec 50 1meg 100g
wrdata ac_176.txt v(outp0) v(outn0) v(vid0) v(outp81) v(outn81) v(vid81)
alter Vr0 1.314
alter Vc0 0.243
op
wrdata op_177.txt i(vsupply0) v(xcase0.att_n0) v(xcase0.att_n1) v(xcase0.att_n2) v(xcase0.att_p0) v(xcase0.att_p1) v(xcase0.att_p2) v(cctrl0) v(cm0) v(xcase0.inn) v(xcase0.inp) v(inx0) v(iny0) v(xcase0.nbias) v(outn0) v(outp0) v(xcase0.p_bias) v(xcase0.rc_ct) v(xcase0.rc_gate) v(xcase0.rc_mid) v(rctrl0) v(xcase0.s1) v(xcase0.s2) v(vdd0) i(vsupply81) v(xcase81.att_n0) v(xcase81.att_n1) v(xcase81.att_n2) v(xcase81.att_p0) v(xcase81.att_p1) v(xcase81.att_p2) v(cctrl81) v(cm81) v(xcase81.inn) v(xcase81.inp) v(inx81) v(iny81) v(xcase81.nbias) v(outn81) v(outp81) v(xcase81.p_bias) v(rctrl81) v(xcase81.s1) v(xcase81.s2) v(vdd81)
ac dec 50 1meg 100g
wrdata ac_177.txt v(outp0) v(outn0) v(vid0) v(outp81) v(outn81) v(vid81)
alter Vr0 1.314
alter Vc0 0.27
op
wrdata op_178.txt i(vsupply0) v(xcase0.att_n0) v(xcase0.att_n1) v(xcase0.att_n2) v(xcase0.att_p0) v(xcase0.att_p1) v(xcase0.att_p2) v(cctrl0) v(cm0) v(xcase0.inn) v(xcase0.inp) v(inx0) v(iny0) v(xcase0.nbias) v(outn0) v(outp0) v(xcase0.p_bias) v(xcase0.rc_ct) v(xcase0.rc_gate) v(xcase0.rc_mid) v(rctrl0) v(xcase0.s1) v(xcase0.s2) v(vdd0) i(vsupply81) v(xcase81.att_n0) v(xcase81.att_n1) v(xcase81.att_n2) v(xcase81.att_p0) v(xcase81.att_p1) v(xcase81.att_p2) v(cctrl81) v(cm81) v(xcase81.inn) v(xcase81.inp) v(inx81) v(iny81) v(xcase81.nbias) v(outn81) v(outp81) v(xcase81.p_bias) v(rctrl81) v(xcase81.s1) v(xcase81.s2) v(vdd81)
ac dec 50 1meg 100g
wrdata ac_178.txt v(outp0) v(outn0) v(vid0) v(outp81) v(outn81) v(vid81)
alter Vr0 1.314
alter Vc0 0.297
op
wrdata op_179.txt i(vsupply0) v(xcase0.att_n0) v(xcase0.att_n1) v(xcase0.att_n2) v(xcase0.att_p0) v(xcase0.att_p1) v(xcase0.att_p2) v(cctrl0) v(cm0) v(xcase0.inn) v(xcase0.inp) v(inx0) v(iny0) v(xcase0.nbias) v(outn0) v(outp0) v(xcase0.p_bias) v(xcase0.rc_ct) v(xcase0.rc_gate) v(xcase0.rc_mid) v(rctrl0) v(xcase0.s1) v(xcase0.s2) v(vdd0) i(vsupply81) v(xcase81.att_n0) v(xcase81.att_n1) v(xcase81.att_n2) v(xcase81.att_p0) v(xcase81.att_p1) v(xcase81.att_p2) v(cctrl81) v(cm81) v(xcase81.inn) v(xcase81.inp) v(inx81) v(iny81) v(xcase81.nbias) v(outn81) v(outp81) v(xcase81.p_bias) v(rctrl81) v(xcase81.s1) v(xcase81.s2) v(vdd81)
ac dec 50 1meg 100g
wrdata ac_179.txt v(outp0) v(outn0) v(vid0) v(outp81) v(outn81) v(vid81)
alter Vr0 1.314
alter Vc0 0.324
op
wrdata op_180.txt i(vsupply0) v(xcase0.att_n0) v(xcase0.att_n1) v(xcase0.att_n2) v(xcase0.att_p0) v(xcase0.att_p1) v(xcase0.att_p2) v(cctrl0) v(cm0) v(xcase0.inn) v(xcase0.inp) v(inx0) v(iny0) v(xcase0.nbias) v(outn0) v(outp0) v(xcase0.p_bias) v(xcase0.rc_ct) v(xcase0.rc_gate) v(xcase0.rc_mid) v(rctrl0) v(xcase0.s1) v(xcase0.s2) v(vdd0) i(vsupply81) v(xcase81.att_n0) v(xcase81.att_n1) v(xcase81.att_n2) v(xcase81.att_p0) v(xcase81.att_p1) v(xcase81.att_p2) v(cctrl81) v(cm81) v(xcase81.inn) v(xcase81.inp) v(inx81) v(iny81) v(xcase81.nbias) v(outn81) v(outp81) v(xcase81.p_bias) v(rctrl81) v(xcase81.s1) v(xcase81.s2) v(vdd81)
ac dec 50 1meg 100g
wrdata ac_180.txt v(outp0) v(outn0) v(vid0) v(outp81) v(outn81) v(vid81)
alter Vr0 1.314
alter Vc0 0.351
op
wrdata op_181.txt i(vsupply0) v(xcase0.att_n0) v(xcase0.att_n1) v(xcase0.att_n2) v(xcase0.att_p0) v(xcase0.att_p1) v(xcase0.att_p2) v(cctrl0) v(cm0) v(xcase0.inn) v(xcase0.inp) v(inx0) v(iny0) v(xcase0.nbias) v(outn0) v(outp0) v(xcase0.p_bias) v(xcase0.rc_ct) v(xcase0.rc_gate) v(xcase0.rc_mid) v(rctrl0) v(xcase0.s1) v(xcase0.s2) v(vdd0) i(vsupply81) v(xcase81.att_n0) v(xcase81.att_n1) v(xcase81.att_n2) v(xcase81.att_p0) v(xcase81.att_p1) v(xcase81.att_p2) v(cctrl81) v(cm81) v(xcase81.inn) v(xcase81.inp) v(inx81) v(iny81) v(xcase81.nbias) v(outn81) v(outp81) v(xcase81.p_bias) v(rctrl81) v(xcase81.s1) v(xcase81.s2) v(vdd81)
ac dec 50 1meg 100g
wrdata ac_181.txt v(outp0) v(outn0) v(vid0) v(outp81) v(outn81) v(vid81)
alter Vr0 1.314
alter Vc0 0.378
op
wrdata op_182.txt i(vsupply0) v(xcase0.att_n0) v(xcase0.att_n1) v(xcase0.att_n2) v(xcase0.att_p0) v(xcase0.att_p1) v(xcase0.att_p2) v(cctrl0) v(cm0) v(xcase0.inn) v(xcase0.inp) v(inx0) v(iny0) v(xcase0.nbias) v(outn0) v(outp0) v(xcase0.p_bias) v(xcase0.rc_ct) v(xcase0.rc_gate) v(xcase0.rc_mid) v(rctrl0) v(xcase0.s1) v(xcase0.s2) v(vdd0) i(vsupply81) v(xcase81.att_n0) v(xcase81.att_n1) v(xcase81.att_n2) v(xcase81.att_p0) v(xcase81.att_p1) v(xcase81.att_p2) v(cctrl81) v(cm81) v(xcase81.inn) v(xcase81.inp) v(inx81) v(iny81) v(xcase81.nbias) v(outn81) v(outp81) v(xcase81.p_bias) v(rctrl81) v(xcase81.s1) v(xcase81.s2) v(vdd81)
ac dec 50 1meg 100g
wrdata ac_182.txt v(outp0) v(outn0) v(vid0) v(outp81) v(outn81) v(vid81)
alter Vr0 1.314
alter Vc0 0.405
op
wrdata op_183.txt i(vsupply0) v(xcase0.att_n0) v(xcase0.att_n1) v(xcase0.att_n2) v(xcase0.att_p0) v(xcase0.att_p1) v(xcase0.att_p2) v(cctrl0) v(cm0) v(xcase0.inn) v(xcase0.inp) v(inx0) v(iny0) v(xcase0.nbias) v(outn0) v(outp0) v(xcase0.p_bias) v(xcase0.rc_ct) v(xcase0.rc_gate) v(xcase0.rc_mid) v(rctrl0) v(xcase0.s1) v(xcase0.s2) v(vdd0) i(vsupply81) v(xcase81.att_n0) v(xcase81.att_n1) v(xcase81.att_n2) v(xcase81.att_p0) v(xcase81.att_p1) v(xcase81.att_p2) v(cctrl81) v(cm81) v(xcase81.inn) v(xcase81.inp) v(inx81) v(iny81) v(xcase81.nbias) v(outn81) v(outp81) v(xcase81.p_bias) v(rctrl81) v(xcase81.s1) v(xcase81.s2) v(vdd81)
ac dec 50 1meg 100g
wrdata ac_183.txt v(outp0) v(outn0) v(vid0) v(outp81) v(outn81) v(vid81)
alter Vr0 1.314
alter Vc0 0.432
op
wrdata op_184.txt i(vsupply0) v(xcase0.att_n0) v(xcase0.att_n1) v(xcase0.att_n2) v(xcase0.att_p0) v(xcase0.att_p1) v(xcase0.att_p2) v(cctrl0) v(cm0) v(xcase0.inn) v(xcase0.inp) v(inx0) v(iny0) v(xcase0.nbias) v(outn0) v(outp0) v(xcase0.p_bias) v(xcase0.rc_ct) v(xcase0.rc_gate) v(xcase0.rc_mid) v(rctrl0) v(xcase0.s1) v(xcase0.s2) v(vdd0) i(vsupply81) v(xcase81.att_n0) v(xcase81.att_n1) v(xcase81.att_n2) v(xcase81.att_p0) v(xcase81.att_p1) v(xcase81.att_p2) v(cctrl81) v(cm81) v(xcase81.inn) v(xcase81.inp) v(inx81) v(iny81) v(xcase81.nbias) v(outn81) v(outp81) v(xcase81.p_bias) v(rctrl81) v(xcase81.s1) v(xcase81.s2) v(vdd81)
ac dec 50 1meg 100g
wrdata ac_184.txt v(outp0) v(outn0) v(vid0) v(outp81) v(outn81) v(vid81)
alter Vr0 1.314
alter Vc0 0.459
op
wrdata op_185.txt i(vsupply0) v(xcase0.att_n0) v(xcase0.att_n1) v(xcase0.att_n2) v(xcase0.att_p0) v(xcase0.att_p1) v(xcase0.att_p2) v(cctrl0) v(cm0) v(xcase0.inn) v(xcase0.inp) v(inx0) v(iny0) v(xcase0.nbias) v(outn0) v(outp0) v(xcase0.p_bias) v(xcase0.rc_ct) v(xcase0.rc_gate) v(xcase0.rc_mid) v(rctrl0) v(xcase0.s1) v(xcase0.s2) v(vdd0) i(vsupply81) v(xcase81.att_n0) v(xcase81.att_n1) v(xcase81.att_n2) v(xcase81.att_p0) v(xcase81.att_p1) v(xcase81.att_p2) v(cctrl81) v(cm81) v(xcase81.inn) v(xcase81.inp) v(inx81) v(iny81) v(xcase81.nbias) v(outn81) v(outp81) v(xcase81.p_bias) v(rctrl81) v(xcase81.s1) v(xcase81.s2) v(vdd81)
ac dec 50 1meg 100g
wrdata ac_185.txt v(outp0) v(outn0) v(vid0) v(outp81) v(outn81) v(vid81)
alter Vr0 1.314
alter Vc0 0.486
op
wrdata op_186.txt i(vsupply0) v(xcase0.att_n0) v(xcase0.att_n1) v(xcase0.att_n2) v(xcase0.att_p0) v(xcase0.att_p1) v(xcase0.att_p2) v(cctrl0) v(cm0) v(xcase0.inn) v(xcase0.inp) v(inx0) v(iny0) v(xcase0.nbias) v(outn0) v(outp0) v(xcase0.p_bias) v(xcase0.rc_ct) v(xcase0.rc_gate) v(xcase0.rc_mid) v(rctrl0) v(xcase0.s1) v(xcase0.s2) v(vdd0) i(vsupply81) v(xcase81.att_n0) v(xcase81.att_n1) v(xcase81.att_n2) v(xcase81.att_p0) v(xcase81.att_p1) v(xcase81.att_p2) v(cctrl81) v(cm81) v(xcase81.inn) v(xcase81.inp) v(inx81) v(iny81) v(xcase81.nbias) v(outn81) v(outp81) v(xcase81.p_bias) v(rctrl81) v(xcase81.s1) v(xcase81.s2) v(vdd81)
ac dec 50 1meg 100g
wrdata ac_186.txt v(outp0) v(outn0) v(vid0) v(outp81) v(outn81) v(vid81)
alter Vr0 1.314
alter Vc0 0.513
op
wrdata op_187.txt i(vsupply0) v(xcase0.att_n0) v(xcase0.att_n1) v(xcase0.att_n2) v(xcase0.att_p0) v(xcase0.att_p1) v(xcase0.att_p2) v(cctrl0) v(cm0) v(xcase0.inn) v(xcase0.inp) v(inx0) v(iny0) v(xcase0.nbias) v(outn0) v(outp0) v(xcase0.p_bias) v(xcase0.rc_ct) v(xcase0.rc_gate) v(xcase0.rc_mid) v(rctrl0) v(xcase0.s1) v(xcase0.s2) v(vdd0) i(vsupply81) v(xcase81.att_n0) v(xcase81.att_n1) v(xcase81.att_n2) v(xcase81.att_p0) v(xcase81.att_p1) v(xcase81.att_p2) v(cctrl81) v(cm81) v(xcase81.inn) v(xcase81.inp) v(inx81) v(iny81) v(xcase81.nbias) v(outn81) v(outp81) v(xcase81.p_bias) v(rctrl81) v(xcase81.s1) v(xcase81.s2) v(vdd81)
ac dec 50 1meg 100g
wrdata ac_187.txt v(outp0) v(outn0) v(vid0) v(outp81) v(outn81) v(vid81)
alter Vr0 1.314
alter Vc0 0.54
op
wrdata op_188.txt i(vsupply0) v(xcase0.att_n0) v(xcase0.att_n1) v(xcase0.att_n2) v(xcase0.att_p0) v(xcase0.att_p1) v(xcase0.att_p2) v(cctrl0) v(cm0) v(xcase0.inn) v(xcase0.inp) v(inx0) v(iny0) v(xcase0.nbias) v(outn0) v(outp0) v(xcase0.p_bias) v(xcase0.rc_ct) v(xcase0.rc_gate) v(xcase0.rc_mid) v(rctrl0) v(xcase0.s1) v(xcase0.s2) v(vdd0) i(vsupply81) v(xcase81.att_n0) v(xcase81.att_n1) v(xcase81.att_n2) v(xcase81.att_p0) v(xcase81.att_p1) v(xcase81.att_p2) v(cctrl81) v(cm81) v(xcase81.inn) v(xcase81.inp) v(inx81) v(iny81) v(xcase81.nbias) v(outn81) v(outp81) v(xcase81.p_bias) v(rctrl81) v(xcase81.s1) v(xcase81.s2) v(vdd81)
ac dec 50 1meg 100g
wrdata ac_188.txt v(outp0) v(outn0) v(vid0) v(outp81) v(outn81) v(vid81)
alter Vr0 1.332
alter Vc0 0
op
wrdata op_189.txt i(vsupply0) v(xcase0.att_n0) v(xcase0.att_n1) v(xcase0.att_n2) v(xcase0.att_p0) v(xcase0.att_p1) v(xcase0.att_p2) v(cctrl0) v(cm0) v(xcase0.inn) v(xcase0.inp) v(inx0) v(iny0) v(xcase0.nbias) v(outn0) v(outp0) v(xcase0.p_bias) v(xcase0.rc_ct) v(xcase0.rc_gate) v(xcase0.rc_mid) v(rctrl0) v(xcase0.s1) v(xcase0.s2) v(vdd0) i(vsupply81) v(xcase81.att_n0) v(xcase81.att_n1) v(xcase81.att_n2) v(xcase81.att_p0) v(xcase81.att_p1) v(xcase81.att_p2) v(cctrl81) v(cm81) v(xcase81.inn) v(xcase81.inp) v(inx81) v(iny81) v(xcase81.nbias) v(outn81) v(outp81) v(xcase81.p_bias) v(rctrl81) v(xcase81.s1) v(xcase81.s2) v(vdd81)
ac dec 50 1meg 100g
wrdata ac_189.txt v(outp0) v(outn0) v(vid0) v(outp81) v(outn81) v(vid81)
alter Vr0 1.332
alter Vc0 0.027
op
wrdata op_190.txt i(vsupply0) v(xcase0.att_n0) v(xcase0.att_n1) v(xcase0.att_n2) v(xcase0.att_p0) v(xcase0.att_p1) v(xcase0.att_p2) v(cctrl0) v(cm0) v(xcase0.inn) v(xcase0.inp) v(inx0) v(iny0) v(xcase0.nbias) v(outn0) v(outp0) v(xcase0.p_bias) v(xcase0.rc_ct) v(xcase0.rc_gate) v(xcase0.rc_mid) v(rctrl0) v(xcase0.s1) v(xcase0.s2) v(vdd0) i(vsupply81) v(xcase81.att_n0) v(xcase81.att_n1) v(xcase81.att_n2) v(xcase81.att_p0) v(xcase81.att_p1) v(xcase81.att_p2) v(cctrl81) v(cm81) v(xcase81.inn) v(xcase81.inp) v(inx81) v(iny81) v(xcase81.nbias) v(outn81) v(outp81) v(xcase81.p_bias) v(rctrl81) v(xcase81.s1) v(xcase81.s2) v(vdd81)
ac dec 50 1meg 100g
wrdata ac_190.txt v(outp0) v(outn0) v(vid0) v(outp81) v(outn81) v(vid81)
alter Vr0 1.332
alter Vc0 0.054
op
wrdata op_191.txt i(vsupply0) v(xcase0.att_n0) v(xcase0.att_n1) v(xcase0.att_n2) v(xcase0.att_p0) v(xcase0.att_p1) v(xcase0.att_p2) v(cctrl0) v(cm0) v(xcase0.inn) v(xcase0.inp) v(inx0) v(iny0) v(xcase0.nbias) v(outn0) v(outp0) v(xcase0.p_bias) v(xcase0.rc_ct) v(xcase0.rc_gate) v(xcase0.rc_mid) v(rctrl0) v(xcase0.s1) v(xcase0.s2) v(vdd0) i(vsupply81) v(xcase81.att_n0) v(xcase81.att_n1) v(xcase81.att_n2) v(xcase81.att_p0) v(xcase81.att_p1) v(xcase81.att_p2) v(cctrl81) v(cm81) v(xcase81.inn) v(xcase81.inp) v(inx81) v(iny81) v(xcase81.nbias) v(outn81) v(outp81) v(xcase81.p_bias) v(rctrl81) v(xcase81.s1) v(xcase81.s2) v(vdd81)
ac dec 50 1meg 100g
wrdata ac_191.txt v(outp0) v(outn0) v(vid0) v(outp81) v(outn81) v(vid81)
alter Vr0 1.332
alter Vc0 0.081
op
wrdata op_192.txt i(vsupply0) v(xcase0.att_n0) v(xcase0.att_n1) v(xcase0.att_n2) v(xcase0.att_p0) v(xcase0.att_p1) v(xcase0.att_p2) v(cctrl0) v(cm0) v(xcase0.inn) v(xcase0.inp) v(inx0) v(iny0) v(xcase0.nbias) v(outn0) v(outp0) v(xcase0.p_bias) v(xcase0.rc_ct) v(xcase0.rc_gate) v(xcase0.rc_mid) v(rctrl0) v(xcase0.s1) v(xcase0.s2) v(vdd0) i(vsupply81) v(xcase81.att_n0) v(xcase81.att_n1) v(xcase81.att_n2) v(xcase81.att_p0) v(xcase81.att_p1) v(xcase81.att_p2) v(cctrl81) v(cm81) v(xcase81.inn) v(xcase81.inp) v(inx81) v(iny81) v(xcase81.nbias) v(outn81) v(outp81) v(xcase81.p_bias) v(rctrl81) v(xcase81.s1) v(xcase81.s2) v(vdd81)
ac dec 50 1meg 100g
wrdata ac_192.txt v(outp0) v(outn0) v(vid0) v(outp81) v(outn81) v(vid81)
alter Vr0 1.332
alter Vc0 0.108
op
wrdata op_193.txt i(vsupply0) v(xcase0.att_n0) v(xcase0.att_n1) v(xcase0.att_n2) v(xcase0.att_p0) v(xcase0.att_p1) v(xcase0.att_p2) v(cctrl0) v(cm0) v(xcase0.inn) v(xcase0.inp) v(inx0) v(iny0) v(xcase0.nbias) v(outn0) v(outp0) v(xcase0.p_bias) v(xcase0.rc_ct) v(xcase0.rc_gate) v(xcase0.rc_mid) v(rctrl0) v(xcase0.s1) v(xcase0.s2) v(vdd0) i(vsupply81) v(xcase81.att_n0) v(xcase81.att_n1) v(xcase81.att_n2) v(xcase81.att_p0) v(xcase81.att_p1) v(xcase81.att_p2) v(cctrl81) v(cm81) v(xcase81.inn) v(xcase81.inp) v(inx81) v(iny81) v(xcase81.nbias) v(outn81) v(outp81) v(xcase81.p_bias) v(rctrl81) v(xcase81.s1) v(xcase81.s2) v(vdd81)
ac dec 50 1meg 100g
wrdata ac_193.txt v(outp0) v(outn0) v(vid0) v(outp81) v(outn81) v(vid81)
alter Vr0 1.332
alter Vc0 0.135
op
wrdata op_194.txt i(vsupply0) v(xcase0.att_n0) v(xcase0.att_n1) v(xcase0.att_n2) v(xcase0.att_p0) v(xcase0.att_p1) v(xcase0.att_p2) v(cctrl0) v(cm0) v(xcase0.inn) v(xcase0.inp) v(inx0) v(iny0) v(xcase0.nbias) v(outn0) v(outp0) v(xcase0.p_bias) v(xcase0.rc_ct) v(xcase0.rc_gate) v(xcase0.rc_mid) v(rctrl0) v(xcase0.s1) v(xcase0.s2) v(vdd0) i(vsupply81) v(xcase81.att_n0) v(xcase81.att_n1) v(xcase81.att_n2) v(xcase81.att_p0) v(xcase81.att_p1) v(xcase81.att_p2) v(cctrl81) v(cm81) v(xcase81.inn) v(xcase81.inp) v(inx81) v(iny81) v(xcase81.nbias) v(outn81) v(outp81) v(xcase81.p_bias) v(rctrl81) v(xcase81.s1) v(xcase81.s2) v(vdd81)
ac dec 50 1meg 100g
wrdata ac_194.txt v(outp0) v(outn0) v(vid0) v(outp81) v(outn81) v(vid81)
alter Vr0 1.332
alter Vc0 0.162
op
wrdata op_195.txt i(vsupply0) v(xcase0.att_n0) v(xcase0.att_n1) v(xcase0.att_n2) v(xcase0.att_p0) v(xcase0.att_p1) v(xcase0.att_p2) v(cctrl0) v(cm0) v(xcase0.inn) v(xcase0.inp) v(inx0) v(iny0) v(xcase0.nbias) v(outn0) v(outp0) v(xcase0.p_bias) v(xcase0.rc_ct) v(xcase0.rc_gate) v(xcase0.rc_mid) v(rctrl0) v(xcase0.s1) v(xcase0.s2) v(vdd0) i(vsupply81) v(xcase81.att_n0) v(xcase81.att_n1) v(xcase81.att_n2) v(xcase81.att_p0) v(xcase81.att_p1) v(xcase81.att_p2) v(cctrl81) v(cm81) v(xcase81.inn) v(xcase81.inp) v(inx81) v(iny81) v(xcase81.nbias) v(outn81) v(outp81) v(xcase81.p_bias) v(rctrl81) v(xcase81.s1) v(xcase81.s2) v(vdd81)
ac dec 50 1meg 100g
wrdata ac_195.txt v(outp0) v(outn0) v(vid0) v(outp81) v(outn81) v(vid81)
alter Vr0 1.332
alter Vc0 0.189
op
wrdata op_196.txt i(vsupply0) v(xcase0.att_n0) v(xcase0.att_n1) v(xcase0.att_n2) v(xcase0.att_p0) v(xcase0.att_p1) v(xcase0.att_p2) v(cctrl0) v(cm0) v(xcase0.inn) v(xcase0.inp) v(inx0) v(iny0) v(xcase0.nbias) v(outn0) v(outp0) v(xcase0.p_bias) v(xcase0.rc_ct) v(xcase0.rc_gate) v(xcase0.rc_mid) v(rctrl0) v(xcase0.s1) v(xcase0.s2) v(vdd0) i(vsupply81) v(xcase81.att_n0) v(xcase81.att_n1) v(xcase81.att_n2) v(xcase81.att_p0) v(xcase81.att_p1) v(xcase81.att_p2) v(cctrl81) v(cm81) v(xcase81.inn) v(xcase81.inp) v(inx81) v(iny81) v(xcase81.nbias) v(outn81) v(outp81) v(xcase81.p_bias) v(rctrl81) v(xcase81.s1) v(xcase81.s2) v(vdd81)
ac dec 50 1meg 100g
wrdata ac_196.txt v(outp0) v(outn0) v(vid0) v(outp81) v(outn81) v(vid81)
alter Vr0 1.332
alter Vc0 0.216
op
wrdata op_197.txt i(vsupply0) v(xcase0.att_n0) v(xcase0.att_n1) v(xcase0.att_n2) v(xcase0.att_p0) v(xcase0.att_p1) v(xcase0.att_p2) v(cctrl0) v(cm0) v(xcase0.inn) v(xcase0.inp) v(inx0) v(iny0) v(xcase0.nbias) v(outn0) v(outp0) v(xcase0.p_bias) v(xcase0.rc_ct) v(xcase0.rc_gate) v(xcase0.rc_mid) v(rctrl0) v(xcase0.s1) v(xcase0.s2) v(vdd0) i(vsupply81) v(xcase81.att_n0) v(xcase81.att_n1) v(xcase81.att_n2) v(xcase81.att_p0) v(xcase81.att_p1) v(xcase81.att_p2) v(cctrl81) v(cm81) v(xcase81.inn) v(xcase81.inp) v(inx81) v(iny81) v(xcase81.nbias) v(outn81) v(outp81) v(xcase81.p_bias) v(rctrl81) v(xcase81.s1) v(xcase81.s2) v(vdd81)
ac dec 50 1meg 100g
wrdata ac_197.txt v(outp0) v(outn0) v(vid0) v(outp81) v(outn81) v(vid81)
alter Vr0 1.332
alter Vc0 0.243
op
wrdata op_198.txt i(vsupply0) v(xcase0.att_n0) v(xcase0.att_n1) v(xcase0.att_n2) v(xcase0.att_p0) v(xcase0.att_p1) v(xcase0.att_p2) v(cctrl0) v(cm0) v(xcase0.inn) v(xcase0.inp) v(inx0) v(iny0) v(xcase0.nbias) v(outn0) v(outp0) v(xcase0.p_bias) v(xcase0.rc_ct) v(xcase0.rc_gate) v(xcase0.rc_mid) v(rctrl0) v(xcase0.s1) v(xcase0.s2) v(vdd0) i(vsupply81) v(xcase81.att_n0) v(xcase81.att_n1) v(xcase81.att_n2) v(xcase81.att_p0) v(xcase81.att_p1) v(xcase81.att_p2) v(cctrl81) v(cm81) v(xcase81.inn) v(xcase81.inp) v(inx81) v(iny81) v(xcase81.nbias) v(outn81) v(outp81) v(xcase81.p_bias) v(rctrl81) v(xcase81.s1) v(xcase81.s2) v(vdd81)
ac dec 50 1meg 100g
wrdata ac_198.txt v(outp0) v(outn0) v(vid0) v(outp81) v(outn81) v(vid81)
alter Vr0 1.332
alter Vc0 0.27
op
wrdata op_199.txt i(vsupply0) v(xcase0.att_n0) v(xcase0.att_n1) v(xcase0.att_n2) v(xcase0.att_p0) v(xcase0.att_p1) v(xcase0.att_p2) v(cctrl0) v(cm0) v(xcase0.inn) v(xcase0.inp) v(inx0) v(iny0) v(xcase0.nbias) v(outn0) v(outp0) v(xcase0.p_bias) v(xcase0.rc_ct) v(xcase0.rc_gate) v(xcase0.rc_mid) v(rctrl0) v(xcase0.s1) v(xcase0.s2) v(vdd0) i(vsupply81) v(xcase81.att_n0) v(xcase81.att_n1) v(xcase81.att_n2) v(xcase81.att_p0) v(xcase81.att_p1) v(xcase81.att_p2) v(cctrl81) v(cm81) v(xcase81.inn) v(xcase81.inp) v(inx81) v(iny81) v(xcase81.nbias) v(outn81) v(outp81) v(xcase81.p_bias) v(rctrl81) v(xcase81.s1) v(xcase81.s2) v(vdd81)
ac dec 50 1meg 100g
wrdata ac_199.txt v(outp0) v(outn0) v(vid0) v(outp81) v(outn81) v(vid81)
alter Vr0 1.332
alter Vc0 0.297
op
wrdata op_200.txt i(vsupply0) v(xcase0.att_n0) v(xcase0.att_n1) v(xcase0.att_n2) v(xcase0.att_p0) v(xcase0.att_p1) v(xcase0.att_p2) v(cctrl0) v(cm0) v(xcase0.inn) v(xcase0.inp) v(inx0) v(iny0) v(xcase0.nbias) v(outn0) v(outp0) v(xcase0.p_bias) v(xcase0.rc_ct) v(xcase0.rc_gate) v(xcase0.rc_mid) v(rctrl0) v(xcase0.s1) v(xcase0.s2) v(vdd0) i(vsupply81) v(xcase81.att_n0) v(xcase81.att_n1) v(xcase81.att_n2) v(xcase81.att_p0) v(xcase81.att_p1) v(xcase81.att_p2) v(cctrl81) v(cm81) v(xcase81.inn) v(xcase81.inp) v(inx81) v(iny81) v(xcase81.nbias) v(outn81) v(outp81) v(xcase81.p_bias) v(rctrl81) v(xcase81.s1) v(xcase81.s2) v(vdd81)
ac dec 50 1meg 100g
wrdata ac_200.txt v(outp0) v(outn0) v(vid0) v(outp81) v(outn81) v(vid81)
alter Vr0 1.332
alter Vc0 0.324
op
wrdata op_201.txt i(vsupply0) v(xcase0.att_n0) v(xcase0.att_n1) v(xcase0.att_n2) v(xcase0.att_p0) v(xcase0.att_p1) v(xcase0.att_p2) v(cctrl0) v(cm0) v(xcase0.inn) v(xcase0.inp) v(inx0) v(iny0) v(xcase0.nbias) v(outn0) v(outp0) v(xcase0.p_bias) v(xcase0.rc_ct) v(xcase0.rc_gate) v(xcase0.rc_mid) v(rctrl0) v(xcase0.s1) v(xcase0.s2) v(vdd0) i(vsupply81) v(xcase81.att_n0) v(xcase81.att_n1) v(xcase81.att_n2) v(xcase81.att_p0) v(xcase81.att_p1) v(xcase81.att_p2) v(cctrl81) v(cm81) v(xcase81.inn) v(xcase81.inp) v(inx81) v(iny81) v(xcase81.nbias) v(outn81) v(outp81) v(xcase81.p_bias) v(rctrl81) v(xcase81.s1) v(xcase81.s2) v(vdd81)
ac dec 50 1meg 100g
wrdata ac_201.txt v(outp0) v(outn0) v(vid0) v(outp81) v(outn81) v(vid81)
alter Vr0 1.332
alter Vc0 0.351
op
wrdata op_202.txt i(vsupply0) v(xcase0.att_n0) v(xcase0.att_n1) v(xcase0.att_n2) v(xcase0.att_p0) v(xcase0.att_p1) v(xcase0.att_p2) v(cctrl0) v(cm0) v(xcase0.inn) v(xcase0.inp) v(inx0) v(iny0) v(xcase0.nbias) v(outn0) v(outp0) v(xcase0.p_bias) v(xcase0.rc_ct) v(xcase0.rc_gate) v(xcase0.rc_mid) v(rctrl0) v(xcase0.s1) v(xcase0.s2) v(vdd0) i(vsupply81) v(xcase81.att_n0) v(xcase81.att_n1) v(xcase81.att_n2) v(xcase81.att_p0) v(xcase81.att_p1) v(xcase81.att_p2) v(cctrl81) v(cm81) v(xcase81.inn) v(xcase81.inp) v(inx81) v(iny81) v(xcase81.nbias) v(outn81) v(outp81) v(xcase81.p_bias) v(rctrl81) v(xcase81.s1) v(xcase81.s2) v(vdd81)
ac dec 50 1meg 100g
wrdata ac_202.txt v(outp0) v(outn0) v(vid0) v(outp81) v(outn81) v(vid81)
alter Vr0 1.332
alter Vc0 0.378
op
wrdata op_203.txt i(vsupply0) v(xcase0.att_n0) v(xcase0.att_n1) v(xcase0.att_n2) v(xcase0.att_p0) v(xcase0.att_p1) v(xcase0.att_p2) v(cctrl0) v(cm0) v(xcase0.inn) v(xcase0.inp) v(inx0) v(iny0) v(xcase0.nbias) v(outn0) v(outp0) v(xcase0.p_bias) v(xcase0.rc_ct) v(xcase0.rc_gate) v(xcase0.rc_mid) v(rctrl0) v(xcase0.s1) v(xcase0.s2) v(vdd0) i(vsupply81) v(xcase81.att_n0) v(xcase81.att_n1) v(xcase81.att_n2) v(xcase81.att_p0) v(xcase81.att_p1) v(xcase81.att_p2) v(cctrl81) v(cm81) v(xcase81.inn) v(xcase81.inp) v(inx81) v(iny81) v(xcase81.nbias) v(outn81) v(outp81) v(xcase81.p_bias) v(rctrl81) v(xcase81.s1) v(xcase81.s2) v(vdd81)
ac dec 50 1meg 100g
wrdata ac_203.txt v(outp0) v(outn0) v(vid0) v(outp81) v(outn81) v(vid81)
alter Vr0 1.332
alter Vc0 0.405
op
wrdata op_204.txt i(vsupply0) v(xcase0.att_n0) v(xcase0.att_n1) v(xcase0.att_n2) v(xcase0.att_p0) v(xcase0.att_p1) v(xcase0.att_p2) v(cctrl0) v(cm0) v(xcase0.inn) v(xcase0.inp) v(inx0) v(iny0) v(xcase0.nbias) v(outn0) v(outp0) v(xcase0.p_bias) v(xcase0.rc_ct) v(xcase0.rc_gate) v(xcase0.rc_mid) v(rctrl0) v(xcase0.s1) v(xcase0.s2) v(vdd0) i(vsupply81) v(xcase81.att_n0) v(xcase81.att_n1) v(xcase81.att_n2) v(xcase81.att_p0) v(xcase81.att_p1) v(xcase81.att_p2) v(cctrl81) v(cm81) v(xcase81.inn) v(xcase81.inp) v(inx81) v(iny81) v(xcase81.nbias) v(outn81) v(outp81) v(xcase81.p_bias) v(rctrl81) v(xcase81.s1) v(xcase81.s2) v(vdd81)
ac dec 50 1meg 100g
wrdata ac_204.txt v(outp0) v(outn0) v(vid0) v(outp81) v(outn81) v(vid81)
alter Vr0 1.332
alter Vc0 0.432
op
wrdata op_205.txt i(vsupply0) v(xcase0.att_n0) v(xcase0.att_n1) v(xcase0.att_n2) v(xcase0.att_p0) v(xcase0.att_p1) v(xcase0.att_p2) v(cctrl0) v(cm0) v(xcase0.inn) v(xcase0.inp) v(inx0) v(iny0) v(xcase0.nbias) v(outn0) v(outp0) v(xcase0.p_bias) v(xcase0.rc_ct) v(xcase0.rc_gate) v(xcase0.rc_mid) v(rctrl0) v(xcase0.s1) v(xcase0.s2) v(vdd0) i(vsupply81) v(xcase81.att_n0) v(xcase81.att_n1) v(xcase81.att_n2) v(xcase81.att_p0) v(xcase81.att_p1) v(xcase81.att_p2) v(cctrl81) v(cm81) v(xcase81.inn) v(xcase81.inp) v(inx81) v(iny81) v(xcase81.nbias) v(outn81) v(outp81) v(xcase81.p_bias) v(rctrl81) v(xcase81.s1) v(xcase81.s2) v(vdd81)
ac dec 50 1meg 100g
wrdata ac_205.txt v(outp0) v(outn0) v(vid0) v(outp81) v(outn81) v(vid81)
alter Vr0 1.332
alter Vc0 0.459
op
wrdata op_206.txt i(vsupply0) v(xcase0.att_n0) v(xcase0.att_n1) v(xcase0.att_n2) v(xcase0.att_p0) v(xcase0.att_p1) v(xcase0.att_p2) v(cctrl0) v(cm0) v(xcase0.inn) v(xcase0.inp) v(inx0) v(iny0) v(xcase0.nbias) v(outn0) v(outp0) v(xcase0.p_bias) v(xcase0.rc_ct) v(xcase0.rc_gate) v(xcase0.rc_mid) v(rctrl0) v(xcase0.s1) v(xcase0.s2) v(vdd0) i(vsupply81) v(xcase81.att_n0) v(xcase81.att_n1) v(xcase81.att_n2) v(xcase81.att_p0) v(xcase81.att_p1) v(xcase81.att_p2) v(cctrl81) v(cm81) v(xcase81.inn) v(xcase81.inp) v(inx81) v(iny81) v(xcase81.nbias) v(outn81) v(outp81) v(xcase81.p_bias) v(rctrl81) v(xcase81.s1) v(xcase81.s2) v(vdd81)
ac dec 50 1meg 100g
wrdata ac_206.txt v(outp0) v(outn0) v(vid0) v(outp81) v(outn81) v(vid81)
alter Vr0 1.332
alter Vc0 0.486
op
wrdata op_207.txt i(vsupply0) v(xcase0.att_n0) v(xcase0.att_n1) v(xcase0.att_n2) v(xcase0.att_p0) v(xcase0.att_p1) v(xcase0.att_p2) v(cctrl0) v(cm0) v(xcase0.inn) v(xcase0.inp) v(inx0) v(iny0) v(xcase0.nbias) v(outn0) v(outp0) v(xcase0.p_bias) v(xcase0.rc_ct) v(xcase0.rc_gate) v(xcase0.rc_mid) v(rctrl0) v(xcase0.s1) v(xcase0.s2) v(vdd0) i(vsupply81) v(xcase81.att_n0) v(xcase81.att_n1) v(xcase81.att_n2) v(xcase81.att_p0) v(xcase81.att_p1) v(xcase81.att_p2) v(cctrl81) v(cm81) v(xcase81.inn) v(xcase81.inp) v(inx81) v(iny81) v(xcase81.nbias) v(outn81) v(outp81) v(xcase81.p_bias) v(rctrl81) v(xcase81.s1) v(xcase81.s2) v(vdd81)
ac dec 50 1meg 100g
wrdata ac_207.txt v(outp0) v(outn0) v(vid0) v(outp81) v(outn81) v(vid81)
alter Vr0 1.332
alter Vc0 0.513
op
wrdata op_208.txt i(vsupply0) v(xcase0.att_n0) v(xcase0.att_n1) v(xcase0.att_n2) v(xcase0.att_p0) v(xcase0.att_p1) v(xcase0.att_p2) v(cctrl0) v(cm0) v(xcase0.inn) v(xcase0.inp) v(inx0) v(iny0) v(xcase0.nbias) v(outn0) v(outp0) v(xcase0.p_bias) v(xcase0.rc_ct) v(xcase0.rc_gate) v(xcase0.rc_mid) v(rctrl0) v(xcase0.s1) v(xcase0.s2) v(vdd0) i(vsupply81) v(xcase81.att_n0) v(xcase81.att_n1) v(xcase81.att_n2) v(xcase81.att_p0) v(xcase81.att_p1) v(xcase81.att_p2) v(cctrl81) v(cm81) v(xcase81.inn) v(xcase81.inp) v(inx81) v(iny81) v(xcase81.nbias) v(outn81) v(outp81) v(xcase81.p_bias) v(rctrl81) v(xcase81.s1) v(xcase81.s2) v(vdd81)
ac dec 50 1meg 100g
wrdata ac_208.txt v(outp0) v(outn0) v(vid0) v(outp81) v(outn81) v(vid81)
alter Vr0 1.332
alter Vc0 0.54
op
wrdata op_209.txt i(vsupply0) v(xcase0.att_n0) v(xcase0.att_n1) v(xcase0.att_n2) v(xcase0.att_p0) v(xcase0.att_p1) v(xcase0.att_p2) v(cctrl0) v(cm0) v(xcase0.inn) v(xcase0.inp) v(inx0) v(iny0) v(xcase0.nbias) v(outn0) v(outp0) v(xcase0.p_bias) v(xcase0.rc_ct) v(xcase0.rc_gate) v(xcase0.rc_mid) v(rctrl0) v(xcase0.s1) v(xcase0.s2) v(vdd0) i(vsupply81) v(xcase81.att_n0) v(xcase81.att_n1) v(xcase81.att_n2) v(xcase81.att_p0) v(xcase81.att_p1) v(xcase81.att_p2) v(cctrl81) v(cm81) v(xcase81.inn) v(xcase81.inp) v(inx81) v(iny81) v(xcase81.nbias) v(outn81) v(outp81) v(xcase81.p_bias) v(rctrl81) v(xcase81.s1) v(xcase81.s2) v(vdd81)
ac dec 50 1meg 100g
wrdata ac_209.txt v(outp0) v(outn0) v(vid0) v(outp81) v(outn81) v(vid81)
alter Vr0 1.35
alter Vc0 0
op
wrdata op_210.txt i(vsupply0) v(xcase0.att_n0) v(xcase0.att_n1) v(xcase0.att_n2) v(xcase0.att_p0) v(xcase0.att_p1) v(xcase0.att_p2) v(cctrl0) v(cm0) v(xcase0.inn) v(xcase0.inp) v(inx0) v(iny0) v(xcase0.nbias) v(outn0) v(outp0) v(xcase0.p_bias) v(xcase0.rc_ct) v(xcase0.rc_gate) v(xcase0.rc_mid) v(rctrl0) v(xcase0.s1) v(xcase0.s2) v(vdd0) i(vsupply81) v(xcase81.att_n0) v(xcase81.att_n1) v(xcase81.att_n2) v(xcase81.att_p0) v(xcase81.att_p1) v(xcase81.att_p2) v(cctrl81) v(cm81) v(xcase81.inn) v(xcase81.inp) v(inx81) v(iny81) v(xcase81.nbias) v(outn81) v(outp81) v(xcase81.p_bias) v(rctrl81) v(xcase81.s1) v(xcase81.s2) v(vdd81)
ac dec 50 1meg 100g
wrdata ac_210.txt v(outp0) v(outn0) v(vid0) v(outp81) v(outn81) v(vid81)
alter Vr0 1.35
alter Vc0 0.027
op
wrdata op_211.txt i(vsupply0) v(xcase0.att_n0) v(xcase0.att_n1) v(xcase0.att_n2) v(xcase0.att_p0) v(xcase0.att_p1) v(xcase0.att_p2) v(cctrl0) v(cm0) v(xcase0.inn) v(xcase0.inp) v(inx0) v(iny0) v(xcase0.nbias) v(outn0) v(outp0) v(xcase0.p_bias) v(xcase0.rc_ct) v(xcase0.rc_gate) v(xcase0.rc_mid) v(rctrl0) v(xcase0.s1) v(xcase0.s2) v(vdd0) i(vsupply81) v(xcase81.att_n0) v(xcase81.att_n1) v(xcase81.att_n2) v(xcase81.att_p0) v(xcase81.att_p1) v(xcase81.att_p2) v(cctrl81) v(cm81) v(xcase81.inn) v(xcase81.inp) v(inx81) v(iny81) v(xcase81.nbias) v(outn81) v(outp81) v(xcase81.p_bias) v(rctrl81) v(xcase81.s1) v(xcase81.s2) v(vdd81)
ac dec 50 1meg 100g
wrdata ac_211.txt v(outp0) v(outn0) v(vid0) v(outp81) v(outn81) v(vid81)
alter Vr0 1.35
alter Vc0 0.054
op
wrdata op_212.txt i(vsupply0) v(xcase0.att_n0) v(xcase0.att_n1) v(xcase0.att_n2) v(xcase0.att_p0) v(xcase0.att_p1) v(xcase0.att_p2) v(cctrl0) v(cm0) v(xcase0.inn) v(xcase0.inp) v(inx0) v(iny0) v(xcase0.nbias) v(outn0) v(outp0) v(xcase0.p_bias) v(xcase0.rc_ct) v(xcase0.rc_gate) v(xcase0.rc_mid) v(rctrl0) v(xcase0.s1) v(xcase0.s2) v(vdd0) i(vsupply81) v(xcase81.att_n0) v(xcase81.att_n1) v(xcase81.att_n2) v(xcase81.att_p0) v(xcase81.att_p1) v(xcase81.att_p2) v(cctrl81) v(cm81) v(xcase81.inn) v(xcase81.inp) v(inx81) v(iny81) v(xcase81.nbias) v(outn81) v(outp81) v(xcase81.p_bias) v(rctrl81) v(xcase81.s1) v(xcase81.s2) v(vdd81)
ac dec 50 1meg 100g
wrdata ac_212.txt v(outp0) v(outn0) v(vid0) v(outp81) v(outn81) v(vid81)
alter Vr0 1.35
alter Vc0 0.081
op
wrdata op_213.txt i(vsupply0) v(xcase0.att_n0) v(xcase0.att_n1) v(xcase0.att_n2) v(xcase0.att_p0) v(xcase0.att_p1) v(xcase0.att_p2) v(cctrl0) v(cm0) v(xcase0.inn) v(xcase0.inp) v(inx0) v(iny0) v(xcase0.nbias) v(outn0) v(outp0) v(xcase0.p_bias) v(xcase0.rc_ct) v(xcase0.rc_gate) v(xcase0.rc_mid) v(rctrl0) v(xcase0.s1) v(xcase0.s2) v(vdd0) i(vsupply81) v(xcase81.att_n0) v(xcase81.att_n1) v(xcase81.att_n2) v(xcase81.att_p0) v(xcase81.att_p1) v(xcase81.att_p2) v(cctrl81) v(cm81) v(xcase81.inn) v(xcase81.inp) v(inx81) v(iny81) v(xcase81.nbias) v(outn81) v(outp81) v(xcase81.p_bias) v(rctrl81) v(xcase81.s1) v(xcase81.s2) v(vdd81)
ac dec 50 1meg 100g
wrdata ac_213.txt v(outp0) v(outn0) v(vid0) v(outp81) v(outn81) v(vid81)
alter Vr0 1.35
alter Vc0 0.108
op
wrdata op_214.txt i(vsupply0) v(xcase0.att_n0) v(xcase0.att_n1) v(xcase0.att_n2) v(xcase0.att_p0) v(xcase0.att_p1) v(xcase0.att_p2) v(cctrl0) v(cm0) v(xcase0.inn) v(xcase0.inp) v(inx0) v(iny0) v(xcase0.nbias) v(outn0) v(outp0) v(xcase0.p_bias) v(xcase0.rc_ct) v(xcase0.rc_gate) v(xcase0.rc_mid) v(rctrl0) v(xcase0.s1) v(xcase0.s2) v(vdd0) i(vsupply81) v(xcase81.att_n0) v(xcase81.att_n1) v(xcase81.att_n2) v(xcase81.att_p0) v(xcase81.att_p1) v(xcase81.att_p2) v(cctrl81) v(cm81) v(xcase81.inn) v(xcase81.inp) v(inx81) v(iny81) v(xcase81.nbias) v(outn81) v(outp81) v(xcase81.p_bias) v(rctrl81) v(xcase81.s1) v(xcase81.s2) v(vdd81)
ac dec 50 1meg 100g
wrdata ac_214.txt v(outp0) v(outn0) v(vid0) v(outp81) v(outn81) v(vid81)
alter Vr0 1.35
alter Vc0 0.135
op
wrdata op_215.txt i(vsupply0) v(xcase0.att_n0) v(xcase0.att_n1) v(xcase0.att_n2) v(xcase0.att_p0) v(xcase0.att_p1) v(xcase0.att_p2) v(cctrl0) v(cm0) v(xcase0.inn) v(xcase0.inp) v(inx0) v(iny0) v(xcase0.nbias) v(outn0) v(outp0) v(xcase0.p_bias) v(xcase0.rc_ct) v(xcase0.rc_gate) v(xcase0.rc_mid) v(rctrl0) v(xcase0.s1) v(xcase0.s2) v(vdd0) i(vsupply81) v(xcase81.att_n0) v(xcase81.att_n1) v(xcase81.att_n2) v(xcase81.att_p0) v(xcase81.att_p1) v(xcase81.att_p2) v(cctrl81) v(cm81) v(xcase81.inn) v(xcase81.inp) v(inx81) v(iny81) v(xcase81.nbias) v(outn81) v(outp81) v(xcase81.p_bias) v(rctrl81) v(xcase81.s1) v(xcase81.s2) v(vdd81)
ac dec 50 1meg 100g
wrdata ac_215.txt v(outp0) v(outn0) v(vid0) v(outp81) v(outn81) v(vid81)
alter Vr0 1.35
alter Vc0 0.162
op
wrdata op_216.txt i(vsupply0) v(xcase0.att_n0) v(xcase0.att_n1) v(xcase0.att_n2) v(xcase0.att_p0) v(xcase0.att_p1) v(xcase0.att_p2) v(cctrl0) v(cm0) v(xcase0.inn) v(xcase0.inp) v(inx0) v(iny0) v(xcase0.nbias) v(outn0) v(outp0) v(xcase0.p_bias) v(xcase0.rc_ct) v(xcase0.rc_gate) v(xcase0.rc_mid) v(rctrl0) v(xcase0.s1) v(xcase0.s2) v(vdd0) i(vsupply81) v(xcase81.att_n0) v(xcase81.att_n1) v(xcase81.att_n2) v(xcase81.att_p0) v(xcase81.att_p1) v(xcase81.att_p2) v(cctrl81) v(cm81) v(xcase81.inn) v(xcase81.inp) v(inx81) v(iny81) v(xcase81.nbias) v(outn81) v(outp81) v(xcase81.p_bias) v(rctrl81) v(xcase81.s1) v(xcase81.s2) v(vdd81)
ac dec 50 1meg 100g
wrdata ac_216.txt v(outp0) v(outn0) v(vid0) v(outp81) v(outn81) v(vid81)
alter Vr0 1.35
alter Vc0 0.189
op
wrdata op_217.txt i(vsupply0) v(xcase0.att_n0) v(xcase0.att_n1) v(xcase0.att_n2) v(xcase0.att_p0) v(xcase0.att_p1) v(xcase0.att_p2) v(cctrl0) v(cm0) v(xcase0.inn) v(xcase0.inp) v(inx0) v(iny0) v(xcase0.nbias) v(outn0) v(outp0) v(xcase0.p_bias) v(xcase0.rc_ct) v(xcase0.rc_gate) v(xcase0.rc_mid) v(rctrl0) v(xcase0.s1) v(xcase0.s2) v(vdd0) i(vsupply81) v(xcase81.att_n0) v(xcase81.att_n1) v(xcase81.att_n2) v(xcase81.att_p0) v(xcase81.att_p1) v(xcase81.att_p2) v(cctrl81) v(cm81) v(xcase81.inn) v(xcase81.inp) v(inx81) v(iny81) v(xcase81.nbias) v(outn81) v(outp81) v(xcase81.p_bias) v(rctrl81) v(xcase81.s1) v(xcase81.s2) v(vdd81)
ac dec 50 1meg 100g
wrdata ac_217.txt v(outp0) v(outn0) v(vid0) v(outp81) v(outn81) v(vid81)
alter Vr0 1.35
alter Vc0 0.216
op
wrdata op_218.txt i(vsupply0) v(xcase0.att_n0) v(xcase0.att_n1) v(xcase0.att_n2) v(xcase0.att_p0) v(xcase0.att_p1) v(xcase0.att_p2) v(cctrl0) v(cm0) v(xcase0.inn) v(xcase0.inp) v(inx0) v(iny0) v(xcase0.nbias) v(outn0) v(outp0) v(xcase0.p_bias) v(xcase0.rc_ct) v(xcase0.rc_gate) v(xcase0.rc_mid) v(rctrl0) v(xcase0.s1) v(xcase0.s2) v(vdd0) i(vsupply81) v(xcase81.att_n0) v(xcase81.att_n1) v(xcase81.att_n2) v(xcase81.att_p0) v(xcase81.att_p1) v(xcase81.att_p2) v(cctrl81) v(cm81) v(xcase81.inn) v(xcase81.inp) v(inx81) v(iny81) v(xcase81.nbias) v(outn81) v(outp81) v(xcase81.p_bias) v(rctrl81) v(xcase81.s1) v(xcase81.s2) v(vdd81)
ac dec 50 1meg 100g
wrdata ac_218.txt v(outp0) v(outn0) v(vid0) v(outp81) v(outn81) v(vid81)
alter Vr0 1.35
alter Vc0 0.243
op
wrdata op_219.txt i(vsupply0) v(xcase0.att_n0) v(xcase0.att_n1) v(xcase0.att_n2) v(xcase0.att_p0) v(xcase0.att_p1) v(xcase0.att_p2) v(cctrl0) v(cm0) v(xcase0.inn) v(xcase0.inp) v(inx0) v(iny0) v(xcase0.nbias) v(outn0) v(outp0) v(xcase0.p_bias) v(xcase0.rc_ct) v(xcase0.rc_gate) v(xcase0.rc_mid) v(rctrl0) v(xcase0.s1) v(xcase0.s2) v(vdd0) i(vsupply81) v(xcase81.att_n0) v(xcase81.att_n1) v(xcase81.att_n2) v(xcase81.att_p0) v(xcase81.att_p1) v(xcase81.att_p2) v(cctrl81) v(cm81) v(xcase81.inn) v(xcase81.inp) v(inx81) v(iny81) v(xcase81.nbias) v(outn81) v(outp81) v(xcase81.p_bias) v(rctrl81) v(xcase81.s1) v(xcase81.s2) v(vdd81)
ac dec 50 1meg 100g
wrdata ac_219.txt v(outp0) v(outn0) v(vid0) v(outp81) v(outn81) v(vid81)
alter Vr0 1.35
alter Vc0 0.27
op
wrdata op_220.txt i(vsupply0) v(xcase0.att_n0) v(xcase0.att_n1) v(xcase0.att_n2) v(xcase0.att_p0) v(xcase0.att_p1) v(xcase0.att_p2) v(cctrl0) v(cm0) v(xcase0.inn) v(xcase0.inp) v(inx0) v(iny0) v(xcase0.nbias) v(outn0) v(outp0) v(xcase0.p_bias) v(xcase0.rc_ct) v(xcase0.rc_gate) v(xcase0.rc_mid) v(rctrl0) v(xcase0.s1) v(xcase0.s2) v(vdd0) i(vsupply81) v(xcase81.att_n0) v(xcase81.att_n1) v(xcase81.att_n2) v(xcase81.att_p0) v(xcase81.att_p1) v(xcase81.att_p2) v(cctrl81) v(cm81) v(xcase81.inn) v(xcase81.inp) v(inx81) v(iny81) v(xcase81.nbias) v(outn81) v(outp81) v(xcase81.p_bias) v(rctrl81) v(xcase81.s1) v(xcase81.s2) v(vdd81)
ac dec 50 1meg 100g
wrdata ac_220.txt v(outp0) v(outn0) v(vid0) v(outp81) v(outn81) v(vid81)
alter Vr0 1.35
alter Vc0 0.297
op
wrdata op_221.txt i(vsupply0) v(xcase0.att_n0) v(xcase0.att_n1) v(xcase0.att_n2) v(xcase0.att_p0) v(xcase0.att_p1) v(xcase0.att_p2) v(cctrl0) v(cm0) v(xcase0.inn) v(xcase0.inp) v(inx0) v(iny0) v(xcase0.nbias) v(outn0) v(outp0) v(xcase0.p_bias) v(xcase0.rc_ct) v(xcase0.rc_gate) v(xcase0.rc_mid) v(rctrl0) v(xcase0.s1) v(xcase0.s2) v(vdd0) i(vsupply81) v(xcase81.att_n0) v(xcase81.att_n1) v(xcase81.att_n2) v(xcase81.att_p0) v(xcase81.att_p1) v(xcase81.att_p2) v(cctrl81) v(cm81) v(xcase81.inn) v(xcase81.inp) v(inx81) v(iny81) v(xcase81.nbias) v(outn81) v(outp81) v(xcase81.p_bias) v(rctrl81) v(xcase81.s1) v(xcase81.s2) v(vdd81)
ac dec 50 1meg 100g
wrdata ac_221.txt v(outp0) v(outn0) v(vid0) v(outp81) v(outn81) v(vid81)
alter Vr0 1.35
alter Vc0 0.324
op
wrdata op_222.txt i(vsupply0) v(xcase0.att_n0) v(xcase0.att_n1) v(xcase0.att_n2) v(xcase0.att_p0) v(xcase0.att_p1) v(xcase0.att_p2) v(cctrl0) v(cm0) v(xcase0.inn) v(xcase0.inp) v(inx0) v(iny0) v(xcase0.nbias) v(outn0) v(outp0) v(xcase0.p_bias) v(xcase0.rc_ct) v(xcase0.rc_gate) v(xcase0.rc_mid) v(rctrl0) v(xcase0.s1) v(xcase0.s2) v(vdd0) i(vsupply81) v(xcase81.att_n0) v(xcase81.att_n1) v(xcase81.att_n2) v(xcase81.att_p0) v(xcase81.att_p1) v(xcase81.att_p2) v(cctrl81) v(cm81) v(xcase81.inn) v(xcase81.inp) v(inx81) v(iny81) v(xcase81.nbias) v(outn81) v(outp81) v(xcase81.p_bias) v(rctrl81) v(xcase81.s1) v(xcase81.s2) v(vdd81)
ac dec 50 1meg 100g
wrdata ac_222.txt v(outp0) v(outn0) v(vid0) v(outp81) v(outn81) v(vid81)
alter Vr0 1.35
alter Vc0 0.351
op
wrdata op_223.txt i(vsupply0) v(xcase0.att_n0) v(xcase0.att_n1) v(xcase0.att_n2) v(xcase0.att_p0) v(xcase0.att_p1) v(xcase0.att_p2) v(cctrl0) v(cm0) v(xcase0.inn) v(xcase0.inp) v(inx0) v(iny0) v(xcase0.nbias) v(outn0) v(outp0) v(xcase0.p_bias) v(xcase0.rc_ct) v(xcase0.rc_gate) v(xcase0.rc_mid) v(rctrl0) v(xcase0.s1) v(xcase0.s2) v(vdd0) i(vsupply81) v(xcase81.att_n0) v(xcase81.att_n1) v(xcase81.att_n2) v(xcase81.att_p0) v(xcase81.att_p1) v(xcase81.att_p2) v(cctrl81) v(cm81) v(xcase81.inn) v(xcase81.inp) v(inx81) v(iny81) v(xcase81.nbias) v(outn81) v(outp81) v(xcase81.p_bias) v(rctrl81) v(xcase81.s1) v(xcase81.s2) v(vdd81)
ac dec 50 1meg 100g
wrdata ac_223.txt v(outp0) v(outn0) v(vid0) v(outp81) v(outn81) v(vid81)
alter Vr0 1.35
alter Vc0 0.378
op
wrdata op_224.txt i(vsupply0) v(xcase0.att_n0) v(xcase0.att_n1) v(xcase0.att_n2) v(xcase0.att_p0) v(xcase0.att_p1) v(xcase0.att_p2) v(cctrl0) v(cm0) v(xcase0.inn) v(xcase0.inp) v(inx0) v(iny0) v(xcase0.nbias) v(outn0) v(outp0) v(xcase0.p_bias) v(xcase0.rc_ct) v(xcase0.rc_gate) v(xcase0.rc_mid) v(rctrl0) v(xcase0.s1) v(xcase0.s2) v(vdd0) i(vsupply81) v(xcase81.att_n0) v(xcase81.att_n1) v(xcase81.att_n2) v(xcase81.att_p0) v(xcase81.att_p1) v(xcase81.att_p2) v(cctrl81) v(cm81) v(xcase81.inn) v(xcase81.inp) v(inx81) v(iny81) v(xcase81.nbias) v(outn81) v(outp81) v(xcase81.p_bias) v(rctrl81) v(xcase81.s1) v(xcase81.s2) v(vdd81)
ac dec 50 1meg 100g
wrdata ac_224.txt v(outp0) v(outn0) v(vid0) v(outp81) v(outn81) v(vid81)
alter Vr0 1.35
alter Vc0 0.405
op
wrdata op_225.txt i(vsupply0) v(xcase0.att_n0) v(xcase0.att_n1) v(xcase0.att_n2) v(xcase0.att_p0) v(xcase0.att_p1) v(xcase0.att_p2) v(cctrl0) v(cm0) v(xcase0.inn) v(xcase0.inp) v(inx0) v(iny0) v(xcase0.nbias) v(outn0) v(outp0) v(xcase0.p_bias) v(xcase0.rc_ct) v(xcase0.rc_gate) v(xcase0.rc_mid) v(rctrl0) v(xcase0.s1) v(xcase0.s2) v(vdd0) i(vsupply81) v(xcase81.att_n0) v(xcase81.att_n1) v(xcase81.att_n2) v(xcase81.att_p0) v(xcase81.att_p1) v(xcase81.att_p2) v(cctrl81) v(cm81) v(xcase81.inn) v(xcase81.inp) v(inx81) v(iny81) v(xcase81.nbias) v(outn81) v(outp81) v(xcase81.p_bias) v(rctrl81) v(xcase81.s1) v(xcase81.s2) v(vdd81)
ac dec 50 1meg 100g
wrdata ac_225.txt v(outp0) v(outn0) v(vid0) v(outp81) v(outn81) v(vid81)
alter Vr0 1.35
alter Vc0 0.432
op
wrdata op_226.txt i(vsupply0) v(xcase0.att_n0) v(xcase0.att_n1) v(xcase0.att_n2) v(xcase0.att_p0) v(xcase0.att_p1) v(xcase0.att_p2) v(cctrl0) v(cm0) v(xcase0.inn) v(xcase0.inp) v(inx0) v(iny0) v(xcase0.nbias) v(outn0) v(outp0) v(xcase0.p_bias) v(xcase0.rc_ct) v(xcase0.rc_gate) v(xcase0.rc_mid) v(rctrl0) v(xcase0.s1) v(xcase0.s2) v(vdd0) i(vsupply81) v(xcase81.att_n0) v(xcase81.att_n1) v(xcase81.att_n2) v(xcase81.att_p0) v(xcase81.att_p1) v(xcase81.att_p2) v(cctrl81) v(cm81) v(xcase81.inn) v(xcase81.inp) v(inx81) v(iny81) v(xcase81.nbias) v(outn81) v(outp81) v(xcase81.p_bias) v(rctrl81) v(xcase81.s1) v(xcase81.s2) v(vdd81)
ac dec 50 1meg 100g
wrdata ac_226.txt v(outp0) v(outn0) v(vid0) v(outp81) v(outn81) v(vid81)
alter Vr0 1.35
alter Vc0 0.459
op
wrdata op_227.txt i(vsupply0) v(xcase0.att_n0) v(xcase0.att_n1) v(xcase0.att_n2) v(xcase0.att_p0) v(xcase0.att_p1) v(xcase0.att_p2) v(cctrl0) v(cm0) v(xcase0.inn) v(xcase0.inp) v(inx0) v(iny0) v(xcase0.nbias) v(outn0) v(outp0) v(xcase0.p_bias) v(xcase0.rc_ct) v(xcase0.rc_gate) v(xcase0.rc_mid) v(rctrl0) v(xcase0.s1) v(xcase0.s2) v(vdd0) i(vsupply81) v(xcase81.att_n0) v(xcase81.att_n1) v(xcase81.att_n2) v(xcase81.att_p0) v(xcase81.att_p1) v(xcase81.att_p2) v(cctrl81) v(cm81) v(xcase81.inn) v(xcase81.inp) v(inx81) v(iny81) v(xcase81.nbias) v(outn81) v(outp81) v(xcase81.p_bias) v(rctrl81) v(xcase81.s1) v(xcase81.s2) v(vdd81)
ac dec 50 1meg 100g
wrdata ac_227.txt v(outp0) v(outn0) v(vid0) v(outp81) v(outn81) v(vid81)
alter Vr0 1.35
alter Vc0 0.486
op
wrdata op_228.txt i(vsupply0) v(xcase0.att_n0) v(xcase0.att_n1) v(xcase0.att_n2) v(xcase0.att_p0) v(xcase0.att_p1) v(xcase0.att_p2) v(cctrl0) v(cm0) v(xcase0.inn) v(xcase0.inp) v(inx0) v(iny0) v(xcase0.nbias) v(outn0) v(outp0) v(xcase0.p_bias) v(xcase0.rc_ct) v(xcase0.rc_gate) v(xcase0.rc_mid) v(rctrl0) v(xcase0.s1) v(xcase0.s2) v(vdd0) i(vsupply81) v(xcase81.att_n0) v(xcase81.att_n1) v(xcase81.att_n2) v(xcase81.att_p0) v(xcase81.att_p1) v(xcase81.att_p2) v(cctrl81) v(cm81) v(xcase81.inn) v(xcase81.inp) v(inx81) v(iny81) v(xcase81.nbias) v(outn81) v(outp81) v(xcase81.p_bias) v(rctrl81) v(xcase81.s1) v(xcase81.s2) v(vdd81)
ac dec 50 1meg 100g
wrdata ac_228.txt v(outp0) v(outn0) v(vid0) v(outp81) v(outn81) v(vid81)
alter Vr0 1.35
alter Vc0 0.513
op
wrdata op_229.txt i(vsupply0) v(xcase0.att_n0) v(xcase0.att_n1) v(xcase0.att_n2) v(xcase0.att_p0) v(xcase0.att_p1) v(xcase0.att_p2) v(cctrl0) v(cm0) v(xcase0.inn) v(xcase0.inp) v(inx0) v(iny0) v(xcase0.nbias) v(outn0) v(outp0) v(xcase0.p_bias) v(xcase0.rc_ct) v(xcase0.rc_gate) v(xcase0.rc_mid) v(rctrl0) v(xcase0.s1) v(xcase0.s2) v(vdd0) i(vsupply81) v(xcase81.att_n0) v(xcase81.att_n1) v(xcase81.att_n2) v(xcase81.att_p0) v(xcase81.att_p1) v(xcase81.att_p2) v(cctrl81) v(cm81) v(xcase81.inn) v(xcase81.inp) v(inx81) v(iny81) v(xcase81.nbias) v(outn81) v(outp81) v(xcase81.p_bias) v(rctrl81) v(xcase81.s1) v(xcase81.s2) v(vdd81)
ac dec 50 1meg 100g
wrdata ac_229.txt v(outp0) v(outn0) v(vid0) v(outp81) v(outn81) v(vid81)
alter Vr0 1.35
alter Vc0 0.54
op
wrdata op_230.txt i(vsupply0) v(xcase0.att_n0) v(xcase0.att_n1) v(xcase0.att_n2) v(xcase0.att_p0) v(xcase0.att_p1) v(xcase0.att_p2) v(cctrl0) v(cm0) v(xcase0.inn) v(xcase0.inp) v(inx0) v(iny0) v(xcase0.nbias) v(outn0) v(outp0) v(xcase0.p_bias) v(xcase0.rc_ct) v(xcase0.rc_gate) v(xcase0.rc_mid) v(rctrl0) v(xcase0.s1) v(xcase0.s2) v(vdd0) i(vsupply81) v(xcase81.att_n0) v(xcase81.att_n1) v(xcase81.att_n2) v(xcase81.att_p0) v(xcase81.att_p1) v(xcase81.att_p2) v(cctrl81) v(cm81) v(xcase81.inn) v(xcase81.inp) v(inx81) v(iny81) v(xcase81.nbias) v(outn81) v(outp81) v(xcase81.p_bias) v(rctrl81) v(xcase81.s1) v(xcase81.s2) v(vdd81)
ac dec 50 1meg 100g
wrdata ac_230.txt v(outp0) v(outn0) v(vid0) v(outp81) v(outn81) v(vid81)
alter Vr0 1.368
alter Vc0 0
op
wrdata op_231.txt i(vsupply0) v(xcase0.att_n0) v(xcase0.att_n1) v(xcase0.att_n2) v(xcase0.att_p0) v(xcase0.att_p1) v(xcase0.att_p2) v(cctrl0) v(cm0) v(xcase0.inn) v(xcase0.inp) v(inx0) v(iny0) v(xcase0.nbias) v(outn0) v(outp0) v(xcase0.p_bias) v(xcase0.rc_ct) v(xcase0.rc_gate) v(xcase0.rc_mid) v(rctrl0) v(xcase0.s1) v(xcase0.s2) v(vdd0) i(vsupply81) v(xcase81.att_n0) v(xcase81.att_n1) v(xcase81.att_n2) v(xcase81.att_p0) v(xcase81.att_p1) v(xcase81.att_p2) v(cctrl81) v(cm81) v(xcase81.inn) v(xcase81.inp) v(inx81) v(iny81) v(xcase81.nbias) v(outn81) v(outp81) v(xcase81.p_bias) v(rctrl81) v(xcase81.s1) v(xcase81.s2) v(vdd81)
ac dec 50 1meg 100g
wrdata ac_231.txt v(outp0) v(outn0) v(vid0) v(outp81) v(outn81) v(vid81)
alter Vr0 1.368
alter Vc0 0.027
op
wrdata op_232.txt i(vsupply0) v(xcase0.att_n0) v(xcase0.att_n1) v(xcase0.att_n2) v(xcase0.att_p0) v(xcase0.att_p1) v(xcase0.att_p2) v(cctrl0) v(cm0) v(xcase0.inn) v(xcase0.inp) v(inx0) v(iny0) v(xcase0.nbias) v(outn0) v(outp0) v(xcase0.p_bias) v(xcase0.rc_ct) v(xcase0.rc_gate) v(xcase0.rc_mid) v(rctrl0) v(xcase0.s1) v(xcase0.s2) v(vdd0) i(vsupply81) v(xcase81.att_n0) v(xcase81.att_n1) v(xcase81.att_n2) v(xcase81.att_p0) v(xcase81.att_p1) v(xcase81.att_p2) v(cctrl81) v(cm81) v(xcase81.inn) v(xcase81.inp) v(inx81) v(iny81) v(xcase81.nbias) v(outn81) v(outp81) v(xcase81.p_bias) v(rctrl81) v(xcase81.s1) v(xcase81.s2) v(vdd81)
ac dec 50 1meg 100g
wrdata ac_232.txt v(outp0) v(outn0) v(vid0) v(outp81) v(outn81) v(vid81)
alter Vr0 1.368
alter Vc0 0.054
op
wrdata op_233.txt i(vsupply0) v(xcase0.att_n0) v(xcase0.att_n1) v(xcase0.att_n2) v(xcase0.att_p0) v(xcase0.att_p1) v(xcase0.att_p2) v(cctrl0) v(cm0) v(xcase0.inn) v(xcase0.inp) v(inx0) v(iny0) v(xcase0.nbias) v(outn0) v(outp0) v(xcase0.p_bias) v(xcase0.rc_ct) v(xcase0.rc_gate) v(xcase0.rc_mid) v(rctrl0) v(xcase0.s1) v(xcase0.s2) v(vdd0) i(vsupply81) v(xcase81.att_n0) v(xcase81.att_n1) v(xcase81.att_n2) v(xcase81.att_p0) v(xcase81.att_p1) v(xcase81.att_p2) v(cctrl81) v(cm81) v(xcase81.inn) v(xcase81.inp) v(inx81) v(iny81) v(xcase81.nbias) v(outn81) v(outp81) v(xcase81.p_bias) v(rctrl81) v(xcase81.s1) v(xcase81.s2) v(vdd81)
ac dec 50 1meg 100g
wrdata ac_233.txt v(outp0) v(outn0) v(vid0) v(outp81) v(outn81) v(vid81)
alter Vr0 1.368
alter Vc0 0.081
op
wrdata op_234.txt i(vsupply0) v(xcase0.att_n0) v(xcase0.att_n1) v(xcase0.att_n2) v(xcase0.att_p0) v(xcase0.att_p1) v(xcase0.att_p2) v(cctrl0) v(cm0) v(xcase0.inn) v(xcase0.inp) v(inx0) v(iny0) v(xcase0.nbias) v(outn0) v(outp0) v(xcase0.p_bias) v(xcase0.rc_ct) v(xcase0.rc_gate) v(xcase0.rc_mid) v(rctrl0) v(xcase0.s1) v(xcase0.s2) v(vdd0) i(vsupply81) v(xcase81.att_n0) v(xcase81.att_n1) v(xcase81.att_n2) v(xcase81.att_p0) v(xcase81.att_p1) v(xcase81.att_p2) v(cctrl81) v(cm81) v(xcase81.inn) v(xcase81.inp) v(inx81) v(iny81) v(xcase81.nbias) v(outn81) v(outp81) v(xcase81.p_bias) v(rctrl81) v(xcase81.s1) v(xcase81.s2) v(vdd81)
ac dec 50 1meg 100g
wrdata ac_234.txt v(outp0) v(outn0) v(vid0) v(outp81) v(outn81) v(vid81)
alter Vr0 1.368
alter Vc0 0.108
op
wrdata op_235.txt i(vsupply0) v(xcase0.att_n0) v(xcase0.att_n1) v(xcase0.att_n2) v(xcase0.att_p0) v(xcase0.att_p1) v(xcase0.att_p2) v(cctrl0) v(cm0) v(xcase0.inn) v(xcase0.inp) v(inx0) v(iny0) v(xcase0.nbias) v(outn0) v(outp0) v(xcase0.p_bias) v(xcase0.rc_ct) v(xcase0.rc_gate) v(xcase0.rc_mid) v(rctrl0) v(xcase0.s1) v(xcase0.s2) v(vdd0) i(vsupply81) v(xcase81.att_n0) v(xcase81.att_n1) v(xcase81.att_n2) v(xcase81.att_p0) v(xcase81.att_p1) v(xcase81.att_p2) v(cctrl81) v(cm81) v(xcase81.inn) v(xcase81.inp) v(inx81) v(iny81) v(xcase81.nbias) v(outn81) v(outp81) v(xcase81.p_bias) v(rctrl81) v(xcase81.s1) v(xcase81.s2) v(vdd81)
ac dec 50 1meg 100g
wrdata ac_235.txt v(outp0) v(outn0) v(vid0) v(outp81) v(outn81) v(vid81)
alter Vr0 1.368
alter Vc0 0.135
op
wrdata op_236.txt i(vsupply0) v(xcase0.att_n0) v(xcase0.att_n1) v(xcase0.att_n2) v(xcase0.att_p0) v(xcase0.att_p1) v(xcase0.att_p2) v(cctrl0) v(cm0) v(xcase0.inn) v(xcase0.inp) v(inx0) v(iny0) v(xcase0.nbias) v(outn0) v(outp0) v(xcase0.p_bias) v(xcase0.rc_ct) v(xcase0.rc_gate) v(xcase0.rc_mid) v(rctrl0) v(xcase0.s1) v(xcase0.s2) v(vdd0) i(vsupply81) v(xcase81.att_n0) v(xcase81.att_n1) v(xcase81.att_n2) v(xcase81.att_p0) v(xcase81.att_p1) v(xcase81.att_p2) v(cctrl81) v(cm81) v(xcase81.inn) v(xcase81.inp) v(inx81) v(iny81) v(xcase81.nbias) v(outn81) v(outp81) v(xcase81.p_bias) v(rctrl81) v(xcase81.s1) v(xcase81.s2) v(vdd81)
ac dec 50 1meg 100g
wrdata ac_236.txt v(outp0) v(outn0) v(vid0) v(outp81) v(outn81) v(vid81)
alter Vr0 1.368
alter Vc0 0.162
op
wrdata op_237.txt i(vsupply0) v(xcase0.att_n0) v(xcase0.att_n1) v(xcase0.att_n2) v(xcase0.att_p0) v(xcase0.att_p1) v(xcase0.att_p2) v(cctrl0) v(cm0) v(xcase0.inn) v(xcase0.inp) v(inx0) v(iny0) v(xcase0.nbias) v(outn0) v(outp0) v(xcase0.p_bias) v(xcase0.rc_ct) v(xcase0.rc_gate) v(xcase0.rc_mid) v(rctrl0) v(xcase0.s1) v(xcase0.s2) v(vdd0) i(vsupply81) v(xcase81.att_n0) v(xcase81.att_n1) v(xcase81.att_n2) v(xcase81.att_p0) v(xcase81.att_p1) v(xcase81.att_p2) v(cctrl81) v(cm81) v(xcase81.inn) v(xcase81.inp) v(inx81) v(iny81) v(xcase81.nbias) v(outn81) v(outp81) v(xcase81.p_bias) v(rctrl81) v(xcase81.s1) v(xcase81.s2) v(vdd81)
ac dec 50 1meg 100g
wrdata ac_237.txt v(outp0) v(outn0) v(vid0) v(outp81) v(outn81) v(vid81)
alter Vr0 1.368
alter Vc0 0.189
op
wrdata op_238.txt i(vsupply0) v(xcase0.att_n0) v(xcase0.att_n1) v(xcase0.att_n2) v(xcase0.att_p0) v(xcase0.att_p1) v(xcase0.att_p2) v(cctrl0) v(cm0) v(xcase0.inn) v(xcase0.inp) v(inx0) v(iny0) v(xcase0.nbias) v(outn0) v(outp0) v(xcase0.p_bias) v(xcase0.rc_ct) v(xcase0.rc_gate) v(xcase0.rc_mid) v(rctrl0) v(xcase0.s1) v(xcase0.s2) v(vdd0) i(vsupply81) v(xcase81.att_n0) v(xcase81.att_n1) v(xcase81.att_n2) v(xcase81.att_p0) v(xcase81.att_p1) v(xcase81.att_p2) v(cctrl81) v(cm81) v(xcase81.inn) v(xcase81.inp) v(inx81) v(iny81) v(xcase81.nbias) v(outn81) v(outp81) v(xcase81.p_bias) v(rctrl81) v(xcase81.s1) v(xcase81.s2) v(vdd81)
ac dec 50 1meg 100g
wrdata ac_238.txt v(outp0) v(outn0) v(vid0) v(outp81) v(outn81) v(vid81)
alter Vr0 1.368
alter Vc0 0.216
op
wrdata op_239.txt i(vsupply0) v(xcase0.att_n0) v(xcase0.att_n1) v(xcase0.att_n2) v(xcase0.att_p0) v(xcase0.att_p1) v(xcase0.att_p2) v(cctrl0) v(cm0) v(xcase0.inn) v(xcase0.inp) v(inx0) v(iny0) v(xcase0.nbias) v(outn0) v(outp0) v(xcase0.p_bias) v(xcase0.rc_ct) v(xcase0.rc_gate) v(xcase0.rc_mid) v(rctrl0) v(xcase0.s1) v(xcase0.s2) v(vdd0) i(vsupply81) v(xcase81.att_n0) v(xcase81.att_n1) v(xcase81.att_n2) v(xcase81.att_p0) v(xcase81.att_p1) v(xcase81.att_p2) v(cctrl81) v(cm81) v(xcase81.inn) v(xcase81.inp) v(inx81) v(iny81) v(xcase81.nbias) v(outn81) v(outp81) v(xcase81.p_bias) v(rctrl81) v(xcase81.s1) v(xcase81.s2) v(vdd81)
ac dec 50 1meg 100g
wrdata ac_239.txt v(outp0) v(outn0) v(vid0) v(outp81) v(outn81) v(vid81)
alter Vr0 1.368
alter Vc0 0.243
op
wrdata op_240.txt i(vsupply0) v(xcase0.att_n0) v(xcase0.att_n1) v(xcase0.att_n2) v(xcase0.att_p0) v(xcase0.att_p1) v(xcase0.att_p2) v(cctrl0) v(cm0) v(xcase0.inn) v(xcase0.inp) v(inx0) v(iny0) v(xcase0.nbias) v(outn0) v(outp0) v(xcase0.p_bias) v(xcase0.rc_ct) v(xcase0.rc_gate) v(xcase0.rc_mid) v(rctrl0) v(xcase0.s1) v(xcase0.s2) v(vdd0) i(vsupply81) v(xcase81.att_n0) v(xcase81.att_n1) v(xcase81.att_n2) v(xcase81.att_p0) v(xcase81.att_p1) v(xcase81.att_p2) v(cctrl81) v(cm81) v(xcase81.inn) v(xcase81.inp) v(inx81) v(iny81) v(xcase81.nbias) v(outn81) v(outp81) v(xcase81.p_bias) v(rctrl81) v(xcase81.s1) v(xcase81.s2) v(vdd81)
ac dec 50 1meg 100g
wrdata ac_240.txt v(outp0) v(outn0) v(vid0) v(outp81) v(outn81) v(vid81)
alter Vr0 1.368
alter Vc0 0.27
op
wrdata op_241.txt i(vsupply0) v(xcase0.att_n0) v(xcase0.att_n1) v(xcase0.att_n2) v(xcase0.att_p0) v(xcase0.att_p1) v(xcase0.att_p2) v(cctrl0) v(cm0) v(xcase0.inn) v(xcase0.inp) v(inx0) v(iny0) v(xcase0.nbias) v(outn0) v(outp0) v(xcase0.p_bias) v(xcase0.rc_ct) v(xcase0.rc_gate) v(xcase0.rc_mid) v(rctrl0) v(xcase0.s1) v(xcase0.s2) v(vdd0) i(vsupply81) v(xcase81.att_n0) v(xcase81.att_n1) v(xcase81.att_n2) v(xcase81.att_p0) v(xcase81.att_p1) v(xcase81.att_p2) v(cctrl81) v(cm81) v(xcase81.inn) v(xcase81.inp) v(inx81) v(iny81) v(xcase81.nbias) v(outn81) v(outp81) v(xcase81.p_bias) v(rctrl81) v(xcase81.s1) v(xcase81.s2) v(vdd81)
ac dec 50 1meg 100g
wrdata ac_241.txt v(outp0) v(outn0) v(vid0) v(outp81) v(outn81) v(vid81)
alter Vr0 1.368
alter Vc0 0.297
op
wrdata op_242.txt i(vsupply0) v(xcase0.att_n0) v(xcase0.att_n1) v(xcase0.att_n2) v(xcase0.att_p0) v(xcase0.att_p1) v(xcase0.att_p2) v(cctrl0) v(cm0) v(xcase0.inn) v(xcase0.inp) v(inx0) v(iny0) v(xcase0.nbias) v(outn0) v(outp0) v(xcase0.p_bias) v(xcase0.rc_ct) v(xcase0.rc_gate) v(xcase0.rc_mid) v(rctrl0) v(xcase0.s1) v(xcase0.s2) v(vdd0) i(vsupply81) v(xcase81.att_n0) v(xcase81.att_n1) v(xcase81.att_n2) v(xcase81.att_p0) v(xcase81.att_p1) v(xcase81.att_p2) v(cctrl81) v(cm81) v(xcase81.inn) v(xcase81.inp) v(inx81) v(iny81) v(xcase81.nbias) v(outn81) v(outp81) v(xcase81.p_bias) v(rctrl81) v(xcase81.s1) v(xcase81.s2) v(vdd81)
ac dec 50 1meg 100g
wrdata ac_242.txt v(outp0) v(outn0) v(vid0) v(outp81) v(outn81) v(vid81)
alter Vr0 1.368
alter Vc0 0.324
op
wrdata op_243.txt i(vsupply0) v(xcase0.att_n0) v(xcase0.att_n1) v(xcase0.att_n2) v(xcase0.att_p0) v(xcase0.att_p1) v(xcase0.att_p2) v(cctrl0) v(cm0) v(xcase0.inn) v(xcase0.inp) v(inx0) v(iny0) v(xcase0.nbias) v(outn0) v(outp0) v(xcase0.p_bias) v(xcase0.rc_ct) v(xcase0.rc_gate) v(xcase0.rc_mid) v(rctrl0) v(xcase0.s1) v(xcase0.s2) v(vdd0) i(vsupply81) v(xcase81.att_n0) v(xcase81.att_n1) v(xcase81.att_n2) v(xcase81.att_p0) v(xcase81.att_p1) v(xcase81.att_p2) v(cctrl81) v(cm81) v(xcase81.inn) v(xcase81.inp) v(inx81) v(iny81) v(xcase81.nbias) v(outn81) v(outp81) v(xcase81.p_bias) v(rctrl81) v(xcase81.s1) v(xcase81.s2) v(vdd81)
ac dec 50 1meg 100g
wrdata ac_243.txt v(outp0) v(outn0) v(vid0) v(outp81) v(outn81) v(vid81)
alter Vr0 1.368
alter Vc0 0.351
op
wrdata op_244.txt i(vsupply0) v(xcase0.att_n0) v(xcase0.att_n1) v(xcase0.att_n2) v(xcase0.att_p0) v(xcase0.att_p1) v(xcase0.att_p2) v(cctrl0) v(cm0) v(xcase0.inn) v(xcase0.inp) v(inx0) v(iny0) v(xcase0.nbias) v(outn0) v(outp0) v(xcase0.p_bias) v(xcase0.rc_ct) v(xcase0.rc_gate) v(xcase0.rc_mid) v(rctrl0) v(xcase0.s1) v(xcase0.s2) v(vdd0) i(vsupply81) v(xcase81.att_n0) v(xcase81.att_n1) v(xcase81.att_n2) v(xcase81.att_p0) v(xcase81.att_p1) v(xcase81.att_p2) v(cctrl81) v(cm81) v(xcase81.inn) v(xcase81.inp) v(inx81) v(iny81) v(xcase81.nbias) v(outn81) v(outp81) v(xcase81.p_bias) v(rctrl81) v(xcase81.s1) v(xcase81.s2) v(vdd81)
ac dec 50 1meg 100g
wrdata ac_244.txt v(outp0) v(outn0) v(vid0) v(outp81) v(outn81) v(vid81)
alter Vr0 1.368
alter Vc0 0.378
op
wrdata op_245.txt i(vsupply0) v(xcase0.att_n0) v(xcase0.att_n1) v(xcase0.att_n2) v(xcase0.att_p0) v(xcase0.att_p1) v(xcase0.att_p2) v(cctrl0) v(cm0) v(xcase0.inn) v(xcase0.inp) v(inx0) v(iny0) v(xcase0.nbias) v(outn0) v(outp0) v(xcase0.p_bias) v(xcase0.rc_ct) v(xcase0.rc_gate) v(xcase0.rc_mid) v(rctrl0) v(xcase0.s1) v(xcase0.s2) v(vdd0) i(vsupply81) v(xcase81.att_n0) v(xcase81.att_n1) v(xcase81.att_n2) v(xcase81.att_p0) v(xcase81.att_p1) v(xcase81.att_p2) v(cctrl81) v(cm81) v(xcase81.inn) v(xcase81.inp) v(inx81) v(iny81) v(xcase81.nbias) v(outn81) v(outp81) v(xcase81.p_bias) v(rctrl81) v(xcase81.s1) v(xcase81.s2) v(vdd81)
ac dec 50 1meg 100g
wrdata ac_245.txt v(outp0) v(outn0) v(vid0) v(outp81) v(outn81) v(vid81)
alter Vr0 1.368
alter Vc0 0.405
op
wrdata op_246.txt i(vsupply0) v(xcase0.att_n0) v(xcase0.att_n1) v(xcase0.att_n2) v(xcase0.att_p0) v(xcase0.att_p1) v(xcase0.att_p2) v(cctrl0) v(cm0) v(xcase0.inn) v(xcase0.inp) v(inx0) v(iny0) v(xcase0.nbias) v(outn0) v(outp0) v(xcase0.p_bias) v(xcase0.rc_ct) v(xcase0.rc_gate) v(xcase0.rc_mid) v(rctrl0) v(xcase0.s1) v(xcase0.s2) v(vdd0) i(vsupply81) v(xcase81.att_n0) v(xcase81.att_n1) v(xcase81.att_n2) v(xcase81.att_p0) v(xcase81.att_p1) v(xcase81.att_p2) v(cctrl81) v(cm81) v(xcase81.inn) v(xcase81.inp) v(inx81) v(iny81) v(xcase81.nbias) v(outn81) v(outp81) v(xcase81.p_bias) v(rctrl81) v(xcase81.s1) v(xcase81.s2) v(vdd81)
ac dec 50 1meg 100g
wrdata ac_246.txt v(outp0) v(outn0) v(vid0) v(outp81) v(outn81) v(vid81)
alter Vr0 1.368
alter Vc0 0.432
op
wrdata op_247.txt i(vsupply0) v(xcase0.att_n0) v(xcase0.att_n1) v(xcase0.att_n2) v(xcase0.att_p0) v(xcase0.att_p1) v(xcase0.att_p2) v(cctrl0) v(cm0) v(xcase0.inn) v(xcase0.inp) v(inx0) v(iny0) v(xcase0.nbias) v(outn0) v(outp0) v(xcase0.p_bias) v(xcase0.rc_ct) v(xcase0.rc_gate) v(xcase0.rc_mid) v(rctrl0) v(xcase0.s1) v(xcase0.s2) v(vdd0) i(vsupply81) v(xcase81.att_n0) v(xcase81.att_n1) v(xcase81.att_n2) v(xcase81.att_p0) v(xcase81.att_p1) v(xcase81.att_p2) v(cctrl81) v(cm81) v(xcase81.inn) v(xcase81.inp) v(inx81) v(iny81) v(xcase81.nbias) v(outn81) v(outp81) v(xcase81.p_bias) v(rctrl81) v(xcase81.s1) v(xcase81.s2) v(vdd81)
ac dec 50 1meg 100g
wrdata ac_247.txt v(outp0) v(outn0) v(vid0) v(outp81) v(outn81) v(vid81)
alter Vr0 1.368
alter Vc0 0.459
op
wrdata op_248.txt i(vsupply0) v(xcase0.att_n0) v(xcase0.att_n1) v(xcase0.att_n2) v(xcase0.att_p0) v(xcase0.att_p1) v(xcase0.att_p2) v(cctrl0) v(cm0) v(xcase0.inn) v(xcase0.inp) v(inx0) v(iny0) v(xcase0.nbias) v(outn0) v(outp0) v(xcase0.p_bias) v(xcase0.rc_ct) v(xcase0.rc_gate) v(xcase0.rc_mid) v(rctrl0) v(xcase0.s1) v(xcase0.s2) v(vdd0) i(vsupply81) v(xcase81.att_n0) v(xcase81.att_n1) v(xcase81.att_n2) v(xcase81.att_p0) v(xcase81.att_p1) v(xcase81.att_p2) v(cctrl81) v(cm81) v(xcase81.inn) v(xcase81.inp) v(inx81) v(iny81) v(xcase81.nbias) v(outn81) v(outp81) v(xcase81.p_bias) v(rctrl81) v(xcase81.s1) v(xcase81.s2) v(vdd81)
ac dec 50 1meg 100g
wrdata ac_248.txt v(outp0) v(outn0) v(vid0) v(outp81) v(outn81) v(vid81)
alter Vr0 1.368
alter Vc0 0.486
op
wrdata op_249.txt i(vsupply0) v(xcase0.att_n0) v(xcase0.att_n1) v(xcase0.att_n2) v(xcase0.att_p0) v(xcase0.att_p1) v(xcase0.att_p2) v(cctrl0) v(cm0) v(xcase0.inn) v(xcase0.inp) v(inx0) v(iny0) v(xcase0.nbias) v(outn0) v(outp0) v(xcase0.p_bias) v(xcase0.rc_ct) v(xcase0.rc_gate) v(xcase0.rc_mid) v(rctrl0) v(xcase0.s1) v(xcase0.s2) v(vdd0) i(vsupply81) v(xcase81.att_n0) v(xcase81.att_n1) v(xcase81.att_n2) v(xcase81.att_p0) v(xcase81.att_p1) v(xcase81.att_p2) v(cctrl81) v(cm81) v(xcase81.inn) v(xcase81.inp) v(inx81) v(iny81) v(xcase81.nbias) v(outn81) v(outp81) v(xcase81.p_bias) v(rctrl81) v(xcase81.s1) v(xcase81.s2) v(vdd81)
ac dec 50 1meg 100g
wrdata ac_249.txt v(outp0) v(outn0) v(vid0) v(outp81) v(outn81) v(vid81)
alter Vr0 1.368
alter Vc0 0.513
op
wrdata op_250.txt i(vsupply0) v(xcase0.att_n0) v(xcase0.att_n1) v(xcase0.att_n2) v(xcase0.att_p0) v(xcase0.att_p1) v(xcase0.att_p2) v(cctrl0) v(cm0) v(xcase0.inn) v(xcase0.inp) v(inx0) v(iny0) v(xcase0.nbias) v(outn0) v(outp0) v(xcase0.p_bias) v(xcase0.rc_ct) v(xcase0.rc_gate) v(xcase0.rc_mid) v(rctrl0) v(xcase0.s1) v(xcase0.s2) v(vdd0) i(vsupply81) v(xcase81.att_n0) v(xcase81.att_n1) v(xcase81.att_n2) v(xcase81.att_p0) v(xcase81.att_p1) v(xcase81.att_p2) v(cctrl81) v(cm81) v(xcase81.inn) v(xcase81.inp) v(inx81) v(iny81) v(xcase81.nbias) v(outn81) v(outp81) v(xcase81.p_bias) v(rctrl81) v(xcase81.s1) v(xcase81.s2) v(vdd81)
ac dec 50 1meg 100g
wrdata ac_250.txt v(outp0) v(outn0) v(vid0) v(outp81) v(outn81) v(vid81)
alter Vr0 1.368
alter Vc0 0.54
op
wrdata op_251.txt i(vsupply0) v(xcase0.att_n0) v(xcase0.att_n1) v(xcase0.att_n2) v(xcase0.att_p0) v(xcase0.att_p1) v(xcase0.att_p2) v(cctrl0) v(cm0) v(xcase0.inn) v(xcase0.inp) v(inx0) v(iny0) v(xcase0.nbias) v(outn0) v(outp0) v(xcase0.p_bias) v(xcase0.rc_ct) v(xcase0.rc_gate) v(xcase0.rc_mid) v(rctrl0) v(xcase0.s1) v(xcase0.s2) v(vdd0) i(vsupply81) v(xcase81.att_n0) v(xcase81.att_n1) v(xcase81.att_n2) v(xcase81.att_p0) v(xcase81.att_p1) v(xcase81.att_p2) v(cctrl81) v(cm81) v(xcase81.inn) v(xcase81.inp) v(inx81) v(iny81) v(xcase81.nbias) v(outn81) v(outp81) v(xcase81.p_bias) v(rctrl81) v(xcase81.s1) v(xcase81.s2) v(vdd81)
ac dec 50 1meg 100g
wrdata ac_251.txt v(outp0) v(outn0) v(vid0) v(outp81) v(outn81) v(vid81)
alter Vr0 1.386
alter Vc0 0
op
wrdata op_252.txt i(vsupply0) v(xcase0.att_n0) v(xcase0.att_n1) v(xcase0.att_n2) v(xcase0.att_p0) v(xcase0.att_p1) v(xcase0.att_p2) v(cctrl0) v(cm0) v(xcase0.inn) v(xcase0.inp) v(inx0) v(iny0) v(xcase0.nbias) v(outn0) v(outp0) v(xcase0.p_bias) v(xcase0.rc_ct) v(xcase0.rc_gate) v(xcase0.rc_mid) v(rctrl0) v(xcase0.s1) v(xcase0.s2) v(vdd0) i(vsupply81) v(xcase81.att_n0) v(xcase81.att_n1) v(xcase81.att_n2) v(xcase81.att_p0) v(xcase81.att_p1) v(xcase81.att_p2) v(cctrl81) v(cm81) v(xcase81.inn) v(xcase81.inp) v(inx81) v(iny81) v(xcase81.nbias) v(outn81) v(outp81) v(xcase81.p_bias) v(rctrl81) v(xcase81.s1) v(xcase81.s2) v(vdd81)
ac dec 50 1meg 100g
wrdata ac_252.txt v(outp0) v(outn0) v(vid0) v(outp81) v(outn81) v(vid81)
alter Vr0 1.386
alter Vc0 0.027
op
wrdata op_253.txt i(vsupply0) v(xcase0.att_n0) v(xcase0.att_n1) v(xcase0.att_n2) v(xcase0.att_p0) v(xcase0.att_p1) v(xcase0.att_p2) v(cctrl0) v(cm0) v(xcase0.inn) v(xcase0.inp) v(inx0) v(iny0) v(xcase0.nbias) v(outn0) v(outp0) v(xcase0.p_bias) v(xcase0.rc_ct) v(xcase0.rc_gate) v(xcase0.rc_mid) v(rctrl0) v(xcase0.s1) v(xcase0.s2) v(vdd0) i(vsupply81) v(xcase81.att_n0) v(xcase81.att_n1) v(xcase81.att_n2) v(xcase81.att_p0) v(xcase81.att_p1) v(xcase81.att_p2) v(cctrl81) v(cm81) v(xcase81.inn) v(xcase81.inp) v(inx81) v(iny81) v(xcase81.nbias) v(outn81) v(outp81) v(xcase81.p_bias) v(rctrl81) v(xcase81.s1) v(xcase81.s2) v(vdd81)
ac dec 50 1meg 100g
wrdata ac_253.txt v(outp0) v(outn0) v(vid0) v(outp81) v(outn81) v(vid81)
alter Vr0 1.386
alter Vc0 0.054
op
wrdata op_254.txt i(vsupply0) v(xcase0.att_n0) v(xcase0.att_n1) v(xcase0.att_n2) v(xcase0.att_p0) v(xcase0.att_p1) v(xcase0.att_p2) v(cctrl0) v(cm0) v(xcase0.inn) v(xcase0.inp) v(inx0) v(iny0) v(xcase0.nbias) v(outn0) v(outp0) v(xcase0.p_bias) v(xcase0.rc_ct) v(xcase0.rc_gate) v(xcase0.rc_mid) v(rctrl0) v(xcase0.s1) v(xcase0.s2) v(vdd0) i(vsupply81) v(xcase81.att_n0) v(xcase81.att_n1) v(xcase81.att_n2) v(xcase81.att_p0) v(xcase81.att_p1) v(xcase81.att_p2) v(cctrl81) v(cm81) v(xcase81.inn) v(xcase81.inp) v(inx81) v(iny81) v(xcase81.nbias) v(outn81) v(outp81) v(xcase81.p_bias) v(rctrl81) v(xcase81.s1) v(xcase81.s2) v(vdd81)
ac dec 50 1meg 100g
wrdata ac_254.txt v(outp0) v(outn0) v(vid0) v(outp81) v(outn81) v(vid81)
alter Vr0 1.386
alter Vc0 0.081
op
wrdata op_255.txt i(vsupply0) v(xcase0.att_n0) v(xcase0.att_n1) v(xcase0.att_n2) v(xcase0.att_p0) v(xcase0.att_p1) v(xcase0.att_p2) v(cctrl0) v(cm0) v(xcase0.inn) v(xcase0.inp) v(inx0) v(iny0) v(xcase0.nbias) v(outn0) v(outp0) v(xcase0.p_bias) v(xcase0.rc_ct) v(xcase0.rc_gate) v(xcase0.rc_mid) v(rctrl0) v(xcase0.s1) v(xcase0.s2) v(vdd0) i(vsupply81) v(xcase81.att_n0) v(xcase81.att_n1) v(xcase81.att_n2) v(xcase81.att_p0) v(xcase81.att_p1) v(xcase81.att_p2) v(cctrl81) v(cm81) v(xcase81.inn) v(xcase81.inp) v(inx81) v(iny81) v(xcase81.nbias) v(outn81) v(outp81) v(xcase81.p_bias) v(rctrl81) v(xcase81.s1) v(xcase81.s2) v(vdd81)
ac dec 50 1meg 100g
wrdata ac_255.txt v(outp0) v(outn0) v(vid0) v(outp81) v(outn81) v(vid81)
alter Vr0 1.386
alter Vc0 0.108
op
wrdata op_256.txt i(vsupply0) v(xcase0.att_n0) v(xcase0.att_n1) v(xcase0.att_n2) v(xcase0.att_p0) v(xcase0.att_p1) v(xcase0.att_p2) v(cctrl0) v(cm0) v(xcase0.inn) v(xcase0.inp) v(inx0) v(iny0) v(xcase0.nbias) v(outn0) v(outp0) v(xcase0.p_bias) v(xcase0.rc_ct) v(xcase0.rc_gate) v(xcase0.rc_mid) v(rctrl0) v(xcase0.s1) v(xcase0.s2) v(vdd0) i(vsupply81) v(xcase81.att_n0) v(xcase81.att_n1) v(xcase81.att_n2) v(xcase81.att_p0) v(xcase81.att_p1) v(xcase81.att_p2) v(cctrl81) v(cm81) v(xcase81.inn) v(xcase81.inp) v(inx81) v(iny81) v(xcase81.nbias) v(outn81) v(outp81) v(xcase81.p_bias) v(rctrl81) v(xcase81.s1) v(xcase81.s2) v(vdd81)
ac dec 50 1meg 100g
wrdata ac_256.txt v(outp0) v(outn0) v(vid0) v(outp81) v(outn81) v(vid81)
alter Vr0 1.386
alter Vc0 0.135
op
wrdata op_257.txt i(vsupply0) v(xcase0.att_n0) v(xcase0.att_n1) v(xcase0.att_n2) v(xcase0.att_p0) v(xcase0.att_p1) v(xcase0.att_p2) v(cctrl0) v(cm0) v(xcase0.inn) v(xcase0.inp) v(inx0) v(iny0) v(xcase0.nbias) v(outn0) v(outp0) v(xcase0.p_bias) v(xcase0.rc_ct) v(xcase0.rc_gate) v(xcase0.rc_mid) v(rctrl0) v(xcase0.s1) v(xcase0.s2) v(vdd0) i(vsupply81) v(xcase81.att_n0) v(xcase81.att_n1) v(xcase81.att_n2) v(xcase81.att_p0) v(xcase81.att_p1) v(xcase81.att_p2) v(cctrl81) v(cm81) v(xcase81.inn) v(xcase81.inp) v(inx81) v(iny81) v(xcase81.nbias) v(outn81) v(outp81) v(xcase81.p_bias) v(rctrl81) v(xcase81.s1) v(xcase81.s2) v(vdd81)
ac dec 50 1meg 100g
wrdata ac_257.txt v(outp0) v(outn0) v(vid0) v(outp81) v(outn81) v(vid81)
alter Vr0 1.386
alter Vc0 0.162
op
wrdata op_258.txt i(vsupply0) v(xcase0.att_n0) v(xcase0.att_n1) v(xcase0.att_n2) v(xcase0.att_p0) v(xcase0.att_p1) v(xcase0.att_p2) v(cctrl0) v(cm0) v(xcase0.inn) v(xcase0.inp) v(inx0) v(iny0) v(xcase0.nbias) v(outn0) v(outp0) v(xcase0.p_bias) v(xcase0.rc_ct) v(xcase0.rc_gate) v(xcase0.rc_mid) v(rctrl0) v(xcase0.s1) v(xcase0.s2) v(vdd0) i(vsupply81) v(xcase81.att_n0) v(xcase81.att_n1) v(xcase81.att_n2) v(xcase81.att_p0) v(xcase81.att_p1) v(xcase81.att_p2) v(cctrl81) v(cm81) v(xcase81.inn) v(xcase81.inp) v(inx81) v(iny81) v(xcase81.nbias) v(outn81) v(outp81) v(xcase81.p_bias) v(rctrl81) v(xcase81.s1) v(xcase81.s2) v(vdd81)
ac dec 50 1meg 100g
wrdata ac_258.txt v(outp0) v(outn0) v(vid0) v(outp81) v(outn81) v(vid81)
alter Vr0 1.386
alter Vc0 0.189
op
wrdata op_259.txt i(vsupply0) v(xcase0.att_n0) v(xcase0.att_n1) v(xcase0.att_n2) v(xcase0.att_p0) v(xcase0.att_p1) v(xcase0.att_p2) v(cctrl0) v(cm0) v(xcase0.inn) v(xcase0.inp) v(inx0) v(iny0) v(xcase0.nbias) v(outn0) v(outp0) v(xcase0.p_bias) v(xcase0.rc_ct) v(xcase0.rc_gate) v(xcase0.rc_mid) v(rctrl0) v(xcase0.s1) v(xcase0.s2) v(vdd0) i(vsupply81) v(xcase81.att_n0) v(xcase81.att_n1) v(xcase81.att_n2) v(xcase81.att_p0) v(xcase81.att_p1) v(xcase81.att_p2) v(cctrl81) v(cm81) v(xcase81.inn) v(xcase81.inp) v(inx81) v(iny81) v(xcase81.nbias) v(outn81) v(outp81) v(xcase81.p_bias) v(rctrl81) v(xcase81.s1) v(xcase81.s2) v(vdd81)
ac dec 50 1meg 100g
wrdata ac_259.txt v(outp0) v(outn0) v(vid0) v(outp81) v(outn81) v(vid81)
alter Vr0 1.386
alter Vc0 0.216
op
wrdata op_260.txt i(vsupply0) v(xcase0.att_n0) v(xcase0.att_n1) v(xcase0.att_n2) v(xcase0.att_p0) v(xcase0.att_p1) v(xcase0.att_p2) v(cctrl0) v(cm0) v(xcase0.inn) v(xcase0.inp) v(inx0) v(iny0) v(xcase0.nbias) v(outn0) v(outp0) v(xcase0.p_bias) v(xcase0.rc_ct) v(xcase0.rc_gate) v(xcase0.rc_mid) v(rctrl0) v(xcase0.s1) v(xcase0.s2) v(vdd0) i(vsupply81) v(xcase81.att_n0) v(xcase81.att_n1) v(xcase81.att_n2) v(xcase81.att_p0) v(xcase81.att_p1) v(xcase81.att_p2) v(cctrl81) v(cm81) v(xcase81.inn) v(xcase81.inp) v(inx81) v(iny81) v(xcase81.nbias) v(outn81) v(outp81) v(xcase81.p_bias) v(rctrl81) v(xcase81.s1) v(xcase81.s2) v(vdd81)
ac dec 50 1meg 100g
wrdata ac_260.txt v(outp0) v(outn0) v(vid0) v(outp81) v(outn81) v(vid81)
alter Vr0 1.386
alter Vc0 0.243
op
wrdata op_261.txt i(vsupply0) v(xcase0.att_n0) v(xcase0.att_n1) v(xcase0.att_n2) v(xcase0.att_p0) v(xcase0.att_p1) v(xcase0.att_p2) v(cctrl0) v(cm0) v(xcase0.inn) v(xcase0.inp) v(inx0) v(iny0) v(xcase0.nbias) v(outn0) v(outp0) v(xcase0.p_bias) v(xcase0.rc_ct) v(xcase0.rc_gate) v(xcase0.rc_mid) v(rctrl0) v(xcase0.s1) v(xcase0.s2) v(vdd0) i(vsupply81) v(xcase81.att_n0) v(xcase81.att_n1) v(xcase81.att_n2) v(xcase81.att_p0) v(xcase81.att_p1) v(xcase81.att_p2) v(cctrl81) v(cm81) v(xcase81.inn) v(xcase81.inp) v(inx81) v(iny81) v(xcase81.nbias) v(outn81) v(outp81) v(xcase81.p_bias) v(rctrl81) v(xcase81.s1) v(xcase81.s2) v(vdd81)
ac dec 50 1meg 100g
wrdata ac_261.txt v(outp0) v(outn0) v(vid0) v(outp81) v(outn81) v(vid81)
alter Vr0 1.386
alter Vc0 0.27
op
wrdata op_262.txt i(vsupply0) v(xcase0.att_n0) v(xcase0.att_n1) v(xcase0.att_n2) v(xcase0.att_p0) v(xcase0.att_p1) v(xcase0.att_p2) v(cctrl0) v(cm0) v(xcase0.inn) v(xcase0.inp) v(inx0) v(iny0) v(xcase0.nbias) v(outn0) v(outp0) v(xcase0.p_bias) v(xcase0.rc_ct) v(xcase0.rc_gate) v(xcase0.rc_mid) v(rctrl0) v(xcase0.s1) v(xcase0.s2) v(vdd0) i(vsupply81) v(xcase81.att_n0) v(xcase81.att_n1) v(xcase81.att_n2) v(xcase81.att_p0) v(xcase81.att_p1) v(xcase81.att_p2) v(cctrl81) v(cm81) v(xcase81.inn) v(xcase81.inp) v(inx81) v(iny81) v(xcase81.nbias) v(outn81) v(outp81) v(xcase81.p_bias) v(rctrl81) v(xcase81.s1) v(xcase81.s2) v(vdd81)
ac dec 50 1meg 100g
wrdata ac_262.txt v(outp0) v(outn0) v(vid0) v(outp81) v(outn81) v(vid81)
alter Vr0 1.386
alter Vc0 0.297
op
wrdata op_263.txt i(vsupply0) v(xcase0.att_n0) v(xcase0.att_n1) v(xcase0.att_n2) v(xcase0.att_p0) v(xcase0.att_p1) v(xcase0.att_p2) v(cctrl0) v(cm0) v(xcase0.inn) v(xcase0.inp) v(inx0) v(iny0) v(xcase0.nbias) v(outn0) v(outp0) v(xcase0.p_bias) v(xcase0.rc_ct) v(xcase0.rc_gate) v(xcase0.rc_mid) v(rctrl0) v(xcase0.s1) v(xcase0.s2) v(vdd0) i(vsupply81) v(xcase81.att_n0) v(xcase81.att_n1) v(xcase81.att_n2) v(xcase81.att_p0) v(xcase81.att_p1) v(xcase81.att_p2) v(cctrl81) v(cm81) v(xcase81.inn) v(xcase81.inp) v(inx81) v(iny81) v(xcase81.nbias) v(outn81) v(outp81) v(xcase81.p_bias) v(rctrl81) v(xcase81.s1) v(xcase81.s2) v(vdd81)
ac dec 50 1meg 100g
wrdata ac_263.txt v(outp0) v(outn0) v(vid0) v(outp81) v(outn81) v(vid81)
alter Vr0 1.386
alter Vc0 0.324
op
wrdata op_264.txt i(vsupply0) v(xcase0.att_n0) v(xcase0.att_n1) v(xcase0.att_n2) v(xcase0.att_p0) v(xcase0.att_p1) v(xcase0.att_p2) v(cctrl0) v(cm0) v(xcase0.inn) v(xcase0.inp) v(inx0) v(iny0) v(xcase0.nbias) v(outn0) v(outp0) v(xcase0.p_bias) v(xcase0.rc_ct) v(xcase0.rc_gate) v(xcase0.rc_mid) v(rctrl0) v(xcase0.s1) v(xcase0.s2) v(vdd0) i(vsupply81) v(xcase81.att_n0) v(xcase81.att_n1) v(xcase81.att_n2) v(xcase81.att_p0) v(xcase81.att_p1) v(xcase81.att_p2) v(cctrl81) v(cm81) v(xcase81.inn) v(xcase81.inp) v(inx81) v(iny81) v(xcase81.nbias) v(outn81) v(outp81) v(xcase81.p_bias) v(rctrl81) v(xcase81.s1) v(xcase81.s2) v(vdd81)
ac dec 50 1meg 100g
wrdata ac_264.txt v(outp0) v(outn0) v(vid0) v(outp81) v(outn81) v(vid81)
alter Vr0 1.386
alter Vc0 0.351
op
wrdata op_265.txt i(vsupply0) v(xcase0.att_n0) v(xcase0.att_n1) v(xcase0.att_n2) v(xcase0.att_p0) v(xcase0.att_p1) v(xcase0.att_p2) v(cctrl0) v(cm0) v(xcase0.inn) v(xcase0.inp) v(inx0) v(iny0) v(xcase0.nbias) v(outn0) v(outp0) v(xcase0.p_bias) v(xcase0.rc_ct) v(xcase0.rc_gate) v(xcase0.rc_mid) v(rctrl0) v(xcase0.s1) v(xcase0.s2) v(vdd0) i(vsupply81) v(xcase81.att_n0) v(xcase81.att_n1) v(xcase81.att_n2) v(xcase81.att_p0) v(xcase81.att_p1) v(xcase81.att_p2) v(cctrl81) v(cm81) v(xcase81.inn) v(xcase81.inp) v(inx81) v(iny81) v(xcase81.nbias) v(outn81) v(outp81) v(xcase81.p_bias) v(rctrl81) v(xcase81.s1) v(xcase81.s2) v(vdd81)
ac dec 50 1meg 100g
wrdata ac_265.txt v(outp0) v(outn0) v(vid0) v(outp81) v(outn81) v(vid81)
alter Vr0 1.386
alter Vc0 0.378
op
wrdata op_266.txt i(vsupply0) v(xcase0.att_n0) v(xcase0.att_n1) v(xcase0.att_n2) v(xcase0.att_p0) v(xcase0.att_p1) v(xcase0.att_p2) v(cctrl0) v(cm0) v(xcase0.inn) v(xcase0.inp) v(inx0) v(iny0) v(xcase0.nbias) v(outn0) v(outp0) v(xcase0.p_bias) v(xcase0.rc_ct) v(xcase0.rc_gate) v(xcase0.rc_mid) v(rctrl0) v(xcase0.s1) v(xcase0.s2) v(vdd0) i(vsupply81) v(xcase81.att_n0) v(xcase81.att_n1) v(xcase81.att_n2) v(xcase81.att_p0) v(xcase81.att_p1) v(xcase81.att_p2) v(cctrl81) v(cm81) v(xcase81.inn) v(xcase81.inp) v(inx81) v(iny81) v(xcase81.nbias) v(outn81) v(outp81) v(xcase81.p_bias) v(rctrl81) v(xcase81.s1) v(xcase81.s2) v(vdd81)
ac dec 50 1meg 100g
wrdata ac_266.txt v(outp0) v(outn0) v(vid0) v(outp81) v(outn81) v(vid81)
alter Vr0 1.386
alter Vc0 0.405
op
wrdata op_267.txt i(vsupply0) v(xcase0.att_n0) v(xcase0.att_n1) v(xcase0.att_n2) v(xcase0.att_p0) v(xcase0.att_p1) v(xcase0.att_p2) v(cctrl0) v(cm0) v(xcase0.inn) v(xcase0.inp) v(inx0) v(iny0) v(xcase0.nbias) v(outn0) v(outp0) v(xcase0.p_bias) v(xcase0.rc_ct) v(xcase0.rc_gate) v(xcase0.rc_mid) v(rctrl0) v(xcase0.s1) v(xcase0.s2) v(vdd0) i(vsupply81) v(xcase81.att_n0) v(xcase81.att_n1) v(xcase81.att_n2) v(xcase81.att_p0) v(xcase81.att_p1) v(xcase81.att_p2) v(cctrl81) v(cm81) v(xcase81.inn) v(xcase81.inp) v(inx81) v(iny81) v(xcase81.nbias) v(outn81) v(outp81) v(xcase81.p_bias) v(rctrl81) v(xcase81.s1) v(xcase81.s2) v(vdd81)
ac dec 50 1meg 100g
wrdata ac_267.txt v(outp0) v(outn0) v(vid0) v(outp81) v(outn81) v(vid81)
alter Vr0 1.386
alter Vc0 0.432
op
wrdata op_268.txt i(vsupply0) v(xcase0.att_n0) v(xcase0.att_n1) v(xcase0.att_n2) v(xcase0.att_p0) v(xcase0.att_p1) v(xcase0.att_p2) v(cctrl0) v(cm0) v(xcase0.inn) v(xcase0.inp) v(inx0) v(iny0) v(xcase0.nbias) v(outn0) v(outp0) v(xcase0.p_bias) v(xcase0.rc_ct) v(xcase0.rc_gate) v(xcase0.rc_mid) v(rctrl0) v(xcase0.s1) v(xcase0.s2) v(vdd0) i(vsupply81) v(xcase81.att_n0) v(xcase81.att_n1) v(xcase81.att_n2) v(xcase81.att_p0) v(xcase81.att_p1) v(xcase81.att_p2) v(cctrl81) v(cm81) v(xcase81.inn) v(xcase81.inp) v(inx81) v(iny81) v(xcase81.nbias) v(outn81) v(outp81) v(xcase81.p_bias) v(rctrl81) v(xcase81.s1) v(xcase81.s2) v(vdd81)
ac dec 50 1meg 100g
wrdata ac_268.txt v(outp0) v(outn0) v(vid0) v(outp81) v(outn81) v(vid81)
alter Vr0 1.386
alter Vc0 0.459
op
wrdata op_269.txt i(vsupply0) v(xcase0.att_n0) v(xcase0.att_n1) v(xcase0.att_n2) v(xcase0.att_p0) v(xcase0.att_p1) v(xcase0.att_p2) v(cctrl0) v(cm0) v(xcase0.inn) v(xcase0.inp) v(inx0) v(iny0) v(xcase0.nbias) v(outn0) v(outp0) v(xcase0.p_bias) v(xcase0.rc_ct) v(xcase0.rc_gate) v(xcase0.rc_mid) v(rctrl0) v(xcase0.s1) v(xcase0.s2) v(vdd0) i(vsupply81) v(xcase81.att_n0) v(xcase81.att_n1) v(xcase81.att_n2) v(xcase81.att_p0) v(xcase81.att_p1) v(xcase81.att_p2) v(cctrl81) v(cm81) v(xcase81.inn) v(xcase81.inp) v(inx81) v(iny81) v(xcase81.nbias) v(outn81) v(outp81) v(xcase81.p_bias) v(rctrl81) v(xcase81.s1) v(xcase81.s2) v(vdd81)
ac dec 50 1meg 100g
wrdata ac_269.txt v(outp0) v(outn0) v(vid0) v(outp81) v(outn81) v(vid81)
alter Vr0 1.386
alter Vc0 0.486
op
wrdata op_270.txt i(vsupply0) v(xcase0.att_n0) v(xcase0.att_n1) v(xcase0.att_n2) v(xcase0.att_p0) v(xcase0.att_p1) v(xcase0.att_p2) v(cctrl0) v(cm0) v(xcase0.inn) v(xcase0.inp) v(inx0) v(iny0) v(xcase0.nbias) v(outn0) v(outp0) v(xcase0.p_bias) v(xcase0.rc_ct) v(xcase0.rc_gate) v(xcase0.rc_mid) v(rctrl0) v(xcase0.s1) v(xcase0.s2) v(vdd0) i(vsupply81) v(xcase81.att_n0) v(xcase81.att_n1) v(xcase81.att_n2) v(xcase81.att_p0) v(xcase81.att_p1) v(xcase81.att_p2) v(cctrl81) v(cm81) v(xcase81.inn) v(xcase81.inp) v(inx81) v(iny81) v(xcase81.nbias) v(outn81) v(outp81) v(xcase81.p_bias) v(rctrl81) v(xcase81.s1) v(xcase81.s2) v(vdd81)
ac dec 50 1meg 100g
wrdata ac_270.txt v(outp0) v(outn0) v(vid0) v(outp81) v(outn81) v(vid81)
alter Vr0 1.386
alter Vc0 0.513
op
wrdata op_271.txt i(vsupply0) v(xcase0.att_n0) v(xcase0.att_n1) v(xcase0.att_n2) v(xcase0.att_p0) v(xcase0.att_p1) v(xcase0.att_p2) v(cctrl0) v(cm0) v(xcase0.inn) v(xcase0.inp) v(inx0) v(iny0) v(xcase0.nbias) v(outn0) v(outp0) v(xcase0.p_bias) v(xcase0.rc_ct) v(xcase0.rc_gate) v(xcase0.rc_mid) v(rctrl0) v(xcase0.s1) v(xcase0.s2) v(vdd0) i(vsupply81) v(xcase81.att_n0) v(xcase81.att_n1) v(xcase81.att_n2) v(xcase81.att_p0) v(xcase81.att_p1) v(xcase81.att_p2) v(cctrl81) v(cm81) v(xcase81.inn) v(xcase81.inp) v(inx81) v(iny81) v(xcase81.nbias) v(outn81) v(outp81) v(xcase81.p_bias) v(rctrl81) v(xcase81.s1) v(xcase81.s2) v(vdd81)
ac dec 50 1meg 100g
wrdata ac_271.txt v(outp0) v(outn0) v(vid0) v(outp81) v(outn81) v(vid81)
alter Vr0 1.386
alter Vc0 0.54
op
wrdata op_272.txt i(vsupply0) v(xcase0.att_n0) v(xcase0.att_n1) v(xcase0.att_n2) v(xcase0.att_p0) v(xcase0.att_p1) v(xcase0.att_p2) v(cctrl0) v(cm0) v(xcase0.inn) v(xcase0.inp) v(inx0) v(iny0) v(xcase0.nbias) v(outn0) v(outp0) v(xcase0.p_bias) v(xcase0.rc_ct) v(xcase0.rc_gate) v(xcase0.rc_mid) v(rctrl0) v(xcase0.s1) v(xcase0.s2) v(vdd0) i(vsupply81) v(xcase81.att_n0) v(xcase81.att_n1) v(xcase81.att_n2) v(xcase81.att_p0) v(xcase81.att_p1) v(xcase81.att_p2) v(cctrl81) v(cm81) v(xcase81.inn) v(xcase81.inp) v(inx81) v(iny81) v(xcase81.nbias) v(outn81) v(outp81) v(xcase81.p_bias) v(rctrl81) v(xcase81.s1) v(xcase81.s2) v(vdd81)
ac dec 50 1meg 100g
wrdata ac_272.txt v(outp0) v(outn0) v(vid0) v(outp81) v(outn81) v(vid81)
alter Vr0 1.404
alter Vc0 0
op
wrdata op_273.txt i(vsupply0) v(xcase0.att_n0) v(xcase0.att_n1) v(xcase0.att_n2) v(xcase0.att_p0) v(xcase0.att_p1) v(xcase0.att_p2) v(cctrl0) v(cm0) v(xcase0.inn) v(xcase0.inp) v(inx0) v(iny0) v(xcase0.nbias) v(outn0) v(outp0) v(xcase0.p_bias) v(xcase0.rc_ct) v(xcase0.rc_gate) v(xcase0.rc_mid) v(rctrl0) v(xcase0.s1) v(xcase0.s2) v(vdd0) i(vsupply81) v(xcase81.att_n0) v(xcase81.att_n1) v(xcase81.att_n2) v(xcase81.att_p0) v(xcase81.att_p1) v(xcase81.att_p2) v(cctrl81) v(cm81) v(xcase81.inn) v(xcase81.inp) v(inx81) v(iny81) v(xcase81.nbias) v(outn81) v(outp81) v(xcase81.p_bias) v(rctrl81) v(xcase81.s1) v(xcase81.s2) v(vdd81)
ac dec 50 1meg 100g
wrdata ac_273.txt v(outp0) v(outn0) v(vid0) v(outp81) v(outn81) v(vid81)
alter Vr0 1.404
alter Vc0 0.027
op
wrdata op_274.txt i(vsupply0) v(xcase0.att_n0) v(xcase0.att_n1) v(xcase0.att_n2) v(xcase0.att_p0) v(xcase0.att_p1) v(xcase0.att_p2) v(cctrl0) v(cm0) v(xcase0.inn) v(xcase0.inp) v(inx0) v(iny0) v(xcase0.nbias) v(outn0) v(outp0) v(xcase0.p_bias) v(xcase0.rc_ct) v(xcase0.rc_gate) v(xcase0.rc_mid) v(rctrl0) v(xcase0.s1) v(xcase0.s2) v(vdd0) i(vsupply81) v(xcase81.att_n0) v(xcase81.att_n1) v(xcase81.att_n2) v(xcase81.att_p0) v(xcase81.att_p1) v(xcase81.att_p2) v(cctrl81) v(cm81) v(xcase81.inn) v(xcase81.inp) v(inx81) v(iny81) v(xcase81.nbias) v(outn81) v(outp81) v(xcase81.p_bias) v(rctrl81) v(xcase81.s1) v(xcase81.s2) v(vdd81)
ac dec 50 1meg 100g
wrdata ac_274.txt v(outp0) v(outn0) v(vid0) v(outp81) v(outn81) v(vid81)
alter Vr0 1.404
alter Vc0 0.054
op
wrdata op_275.txt i(vsupply0) v(xcase0.att_n0) v(xcase0.att_n1) v(xcase0.att_n2) v(xcase0.att_p0) v(xcase0.att_p1) v(xcase0.att_p2) v(cctrl0) v(cm0) v(xcase0.inn) v(xcase0.inp) v(inx0) v(iny0) v(xcase0.nbias) v(outn0) v(outp0) v(xcase0.p_bias) v(xcase0.rc_ct) v(xcase0.rc_gate) v(xcase0.rc_mid) v(rctrl0) v(xcase0.s1) v(xcase0.s2) v(vdd0) i(vsupply81) v(xcase81.att_n0) v(xcase81.att_n1) v(xcase81.att_n2) v(xcase81.att_p0) v(xcase81.att_p1) v(xcase81.att_p2) v(cctrl81) v(cm81) v(xcase81.inn) v(xcase81.inp) v(inx81) v(iny81) v(xcase81.nbias) v(outn81) v(outp81) v(xcase81.p_bias) v(rctrl81) v(xcase81.s1) v(xcase81.s2) v(vdd81)
ac dec 50 1meg 100g
wrdata ac_275.txt v(outp0) v(outn0) v(vid0) v(outp81) v(outn81) v(vid81)
alter Vr0 1.404
alter Vc0 0.081
op
wrdata op_276.txt i(vsupply0) v(xcase0.att_n0) v(xcase0.att_n1) v(xcase0.att_n2) v(xcase0.att_p0) v(xcase0.att_p1) v(xcase0.att_p2) v(cctrl0) v(cm0) v(xcase0.inn) v(xcase0.inp) v(inx0) v(iny0) v(xcase0.nbias) v(outn0) v(outp0) v(xcase0.p_bias) v(xcase0.rc_ct) v(xcase0.rc_gate) v(xcase0.rc_mid) v(rctrl0) v(xcase0.s1) v(xcase0.s2) v(vdd0) i(vsupply81) v(xcase81.att_n0) v(xcase81.att_n1) v(xcase81.att_n2) v(xcase81.att_p0) v(xcase81.att_p1) v(xcase81.att_p2) v(cctrl81) v(cm81) v(xcase81.inn) v(xcase81.inp) v(inx81) v(iny81) v(xcase81.nbias) v(outn81) v(outp81) v(xcase81.p_bias) v(rctrl81) v(xcase81.s1) v(xcase81.s2) v(vdd81)
ac dec 50 1meg 100g
wrdata ac_276.txt v(outp0) v(outn0) v(vid0) v(outp81) v(outn81) v(vid81)
alter Vr0 1.404
alter Vc0 0.108
op
wrdata op_277.txt i(vsupply0) v(xcase0.att_n0) v(xcase0.att_n1) v(xcase0.att_n2) v(xcase0.att_p0) v(xcase0.att_p1) v(xcase0.att_p2) v(cctrl0) v(cm0) v(xcase0.inn) v(xcase0.inp) v(inx0) v(iny0) v(xcase0.nbias) v(outn0) v(outp0) v(xcase0.p_bias) v(xcase0.rc_ct) v(xcase0.rc_gate) v(xcase0.rc_mid) v(rctrl0) v(xcase0.s1) v(xcase0.s2) v(vdd0) i(vsupply81) v(xcase81.att_n0) v(xcase81.att_n1) v(xcase81.att_n2) v(xcase81.att_p0) v(xcase81.att_p1) v(xcase81.att_p2) v(cctrl81) v(cm81) v(xcase81.inn) v(xcase81.inp) v(inx81) v(iny81) v(xcase81.nbias) v(outn81) v(outp81) v(xcase81.p_bias) v(rctrl81) v(xcase81.s1) v(xcase81.s2) v(vdd81)
ac dec 50 1meg 100g
wrdata ac_277.txt v(outp0) v(outn0) v(vid0) v(outp81) v(outn81) v(vid81)
alter Vr0 1.404
alter Vc0 0.135
op
wrdata op_278.txt i(vsupply0) v(xcase0.att_n0) v(xcase0.att_n1) v(xcase0.att_n2) v(xcase0.att_p0) v(xcase0.att_p1) v(xcase0.att_p2) v(cctrl0) v(cm0) v(xcase0.inn) v(xcase0.inp) v(inx0) v(iny0) v(xcase0.nbias) v(outn0) v(outp0) v(xcase0.p_bias) v(xcase0.rc_ct) v(xcase0.rc_gate) v(xcase0.rc_mid) v(rctrl0) v(xcase0.s1) v(xcase0.s2) v(vdd0) i(vsupply81) v(xcase81.att_n0) v(xcase81.att_n1) v(xcase81.att_n2) v(xcase81.att_p0) v(xcase81.att_p1) v(xcase81.att_p2) v(cctrl81) v(cm81) v(xcase81.inn) v(xcase81.inp) v(inx81) v(iny81) v(xcase81.nbias) v(outn81) v(outp81) v(xcase81.p_bias) v(rctrl81) v(xcase81.s1) v(xcase81.s2) v(vdd81)
ac dec 50 1meg 100g
wrdata ac_278.txt v(outp0) v(outn0) v(vid0) v(outp81) v(outn81) v(vid81)
alter Vr0 1.404
alter Vc0 0.162
op
wrdata op_279.txt i(vsupply0) v(xcase0.att_n0) v(xcase0.att_n1) v(xcase0.att_n2) v(xcase0.att_p0) v(xcase0.att_p1) v(xcase0.att_p2) v(cctrl0) v(cm0) v(xcase0.inn) v(xcase0.inp) v(inx0) v(iny0) v(xcase0.nbias) v(outn0) v(outp0) v(xcase0.p_bias) v(xcase0.rc_ct) v(xcase0.rc_gate) v(xcase0.rc_mid) v(rctrl0) v(xcase0.s1) v(xcase0.s2) v(vdd0) i(vsupply81) v(xcase81.att_n0) v(xcase81.att_n1) v(xcase81.att_n2) v(xcase81.att_p0) v(xcase81.att_p1) v(xcase81.att_p2) v(cctrl81) v(cm81) v(xcase81.inn) v(xcase81.inp) v(inx81) v(iny81) v(xcase81.nbias) v(outn81) v(outp81) v(xcase81.p_bias) v(rctrl81) v(xcase81.s1) v(xcase81.s2) v(vdd81)
ac dec 50 1meg 100g
wrdata ac_279.txt v(outp0) v(outn0) v(vid0) v(outp81) v(outn81) v(vid81)
alter Vr0 1.404
alter Vc0 0.189
op
wrdata op_280.txt i(vsupply0) v(xcase0.att_n0) v(xcase0.att_n1) v(xcase0.att_n2) v(xcase0.att_p0) v(xcase0.att_p1) v(xcase0.att_p2) v(cctrl0) v(cm0) v(xcase0.inn) v(xcase0.inp) v(inx0) v(iny0) v(xcase0.nbias) v(outn0) v(outp0) v(xcase0.p_bias) v(xcase0.rc_ct) v(xcase0.rc_gate) v(xcase0.rc_mid) v(rctrl0) v(xcase0.s1) v(xcase0.s2) v(vdd0) i(vsupply81) v(xcase81.att_n0) v(xcase81.att_n1) v(xcase81.att_n2) v(xcase81.att_p0) v(xcase81.att_p1) v(xcase81.att_p2) v(cctrl81) v(cm81) v(xcase81.inn) v(xcase81.inp) v(inx81) v(iny81) v(xcase81.nbias) v(outn81) v(outp81) v(xcase81.p_bias) v(rctrl81) v(xcase81.s1) v(xcase81.s2) v(vdd81)
ac dec 50 1meg 100g
wrdata ac_280.txt v(outp0) v(outn0) v(vid0) v(outp81) v(outn81) v(vid81)
alter Vr0 1.404
alter Vc0 0.216
op
wrdata op_281.txt i(vsupply0) v(xcase0.att_n0) v(xcase0.att_n1) v(xcase0.att_n2) v(xcase0.att_p0) v(xcase0.att_p1) v(xcase0.att_p2) v(cctrl0) v(cm0) v(xcase0.inn) v(xcase0.inp) v(inx0) v(iny0) v(xcase0.nbias) v(outn0) v(outp0) v(xcase0.p_bias) v(xcase0.rc_ct) v(xcase0.rc_gate) v(xcase0.rc_mid) v(rctrl0) v(xcase0.s1) v(xcase0.s2) v(vdd0) i(vsupply81) v(xcase81.att_n0) v(xcase81.att_n1) v(xcase81.att_n2) v(xcase81.att_p0) v(xcase81.att_p1) v(xcase81.att_p2) v(cctrl81) v(cm81) v(xcase81.inn) v(xcase81.inp) v(inx81) v(iny81) v(xcase81.nbias) v(outn81) v(outp81) v(xcase81.p_bias) v(rctrl81) v(xcase81.s1) v(xcase81.s2) v(vdd81)
ac dec 50 1meg 100g
wrdata ac_281.txt v(outp0) v(outn0) v(vid0) v(outp81) v(outn81) v(vid81)
alter Vr0 1.404
alter Vc0 0.243
op
wrdata op_282.txt i(vsupply0) v(xcase0.att_n0) v(xcase0.att_n1) v(xcase0.att_n2) v(xcase0.att_p0) v(xcase0.att_p1) v(xcase0.att_p2) v(cctrl0) v(cm0) v(xcase0.inn) v(xcase0.inp) v(inx0) v(iny0) v(xcase0.nbias) v(outn0) v(outp0) v(xcase0.p_bias) v(xcase0.rc_ct) v(xcase0.rc_gate) v(xcase0.rc_mid) v(rctrl0) v(xcase0.s1) v(xcase0.s2) v(vdd0) i(vsupply81) v(xcase81.att_n0) v(xcase81.att_n1) v(xcase81.att_n2) v(xcase81.att_p0) v(xcase81.att_p1) v(xcase81.att_p2) v(cctrl81) v(cm81) v(xcase81.inn) v(xcase81.inp) v(inx81) v(iny81) v(xcase81.nbias) v(outn81) v(outp81) v(xcase81.p_bias) v(rctrl81) v(xcase81.s1) v(xcase81.s2) v(vdd81)
ac dec 50 1meg 100g
wrdata ac_282.txt v(outp0) v(outn0) v(vid0) v(outp81) v(outn81) v(vid81)
alter Vr0 1.404
alter Vc0 0.27
op
wrdata op_283.txt i(vsupply0) v(xcase0.att_n0) v(xcase0.att_n1) v(xcase0.att_n2) v(xcase0.att_p0) v(xcase0.att_p1) v(xcase0.att_p2) v(cctrl0) v(cm0) v(xcase0.inn) v(xcase0.inp) v(inx0) v(iny0) v(xcase0.nbias) v(outn0) v(outp0) v(xcase0.p_bias) v(xcase0.rc_ct) v(xcase0.rc_gate) v(xcase0.rc_mid) v(rctrl0) v(xcase0.s1) v(xcase0.s2) v(vdd0) i(vsupply81) v(xcase81.att_n0) v(xcase81.att_n1) v(xcase81.att_n2) v(xcase81.att_p0) v(xcase81.att_p1) v(xcase81.att_p2) v(cctrl81) v(cm81) v(xcase81.inn) v(xcase81.inp) v(inx81) v(iny81) v(xcase81.nbias) v(outn81) v(outp81) v(xcase81.p_bias) v(rctrl81) v(xcase81.s1) v(xcase81.s2) v(vdd81)
ac dec 50 1meg 100g
wrdata ac_283.txt v(outp0) v(outn0) v(vid0) v(outp81) v(outn81) v(vid81)
alter Vr0 1.404
alter Vc0 0.297
op
wrdata op_284.txt i(vsupply0) v(xcase0.att_n0) v(xcase0.att_n1) v(xcase0.att_n2) v(xcase0.att_p0) v(xcase0.att_p1) v(xcase0.att_p2) v(cctrl0) v(cm0) v(xcase0.inn) v(xcase0.inp) v(inx0) v(iny0) v(xcase0.nbias) v(outn0) v(outp0) v(xcase0.p_bias) v(xcase0.rc_ct) v(xcase0.rc_gate) v(xcase0.rc_mid) v(rctrl0) v(xcase0.s1) v(xcase0.s2) v(vdd0) i(vsupply81) v(xcase81.att_n0) v(xcase81.att_n1) v(xcase81.att_n2) v(xcase81.att_p0) v(xcase81.att_p1) v(xcase81.att_p2) v(cctrl81) v(cm81) v(xcase81.inn) v(xcase81.inp) v(inx81) v(iny81) v(xcase81.nbias) v(outn81) v(outp81) v(xcase81.p_bias) v(rctrl81) v(xcase81.s1) v(xcase81.s2) v(vdd81)
ac dec 50 1meg 100g
wrdata ac_284.txt v(outp0) v(outn0) v(vid0) v(outp81) v(outn81) v(vid81)
alter Vr0 1.404
alter Vc0 0.324
op
wrdata op_285.txt i(vsupply0) v(xcase0.att_n0) v(xcase0.att_n1) v(xcase0.att_n2) v(xcase0.att_p0) v(xcase0.att_p1) v(xcase0.att_p2) v(cctrl0) v(cm0) v(xcase0.inn) v(xcase0.inp) v(inx0) v(iny0) v(xcase0.nbias) v(outn0) v(outp0) v(xcase0.p_bias) v(xcase0.rc_ct) v(xcase0.rc_gate) v(xcase0.rc_mid) v(rctrl0) v(xcase0.s1) v(xcase0.s2) v(vdd0) i(vsupply81) v(xcase81.att_n0) v(xcase81.att_n1) v(xcase81.att_n2) v(xcase81.att_p0) v(xcase81.att_p1) v(xcase81.att_p2) v(cctrl81) v(cm81) v(xcase81.inn) v(xcase81.inp) v(inx81) v(iny81) v(xcase81.nbias) v(outn81) v(outp81) v(xcase81.p_bias) v(rctrl81) v(xcase81.s1) v(xcase81.s2) v(vdd81)
ac dec 50 1meg 100g
wrdata ac_285.txt v(outp0) v(outn0) v(vid0) v(outp81) v(outn81) v(vid81)
alter Vr0 1.404
alter Vc0 0.351
op
wrdata op_286.txt i(vsupply0) v(xcase0.att_n0) v(xcase0.att_n1) v(xcase0.att_n2) v(xcase0.att_p0) v(xcase0.att_p1) v(xcase0.att_p2) v(cctrl0) v(cm0) v(xcase0.inn) v(xcase0.inp) v(inx0) v(iny0) v(xcase0.nbias) v(outn0) v(outp0) v(xcase0.p_bias) v(xcase0.rc_ct) v(xcase0.rc_gate) v(xcase0.rc_mid) v(rctrl0) v(xcase0.s1) v(xcase0.s2) v(vdd0) i(vsupply81) v(xcase81.att_n0) v(xcase81.att_n1) v(xcase81.att_n2) v(xcase81.att_p0) v(xcase81.att_p1) v(xcase81.att_p2) v(cctrl81) v(cm81) v(xcase81.inn) v(xcase81.inp) v(inx81) v(iny81) v(xcase81.nbias) v(outn81) v(outp81) v(xcase81.p_bias) v(rctrl81) v(xcase81.s1) v(xcase81.s2) v(vdd81)
ac dec 50 1meg 100g
wrdata ac_286.txt v(outp0) v(outn0) v(vid0) v(outp81) v(outn81) v(vid81)
alter Vr0 1.404
alter Vc0 0.378
op
wrdata op_287.txt i(vsupply0) v(xcase0.att_n0) v(xcase0.att_n1) v(xcase0.att_n2) v(xcase0.att_p0) v(xcase0.att_p1) v(xcase0.att_p2) v(cctrl0) v(cm0) v(xcase0.inn) v(xcase0.inp) v(inx0) v(iny0) v(xcase0.nbias) v(outn0) v(outp0) v(xcase0.p_bias) v(xcase0.rc_ct) v(xcase0.rc_gate) v(xcase0.rc_mid) v(rctrl0) v(xcase0.s1) v(xcase0.s2) v(vdd0) i(vsupply81) v(xcase81.att_n0) v(xcase81.att_n1) v(xcase81.att_n2) v(xcase81.att_p0) v(xcase81.att_p1) v(xcase81.att_p2) v(cctrl81) v(cm81) v(xcase81.inn) v(xcase81.inp) v(inx81) v(iny81) v(xcase81.nbias) v(outn81) v(outp81) v(xcase81.p_bias) v(rctrl81) v(xcase81.s1) v(xcase81.s2) v(vdd81)
ac dec 50 1meg 100g
wrdata ac_287.txt v(outp0) v(outn0) v(vid0) v(outp81) v(outn81) v(vid81)
alter Vr0 1.404
alter Vc0 0.405
op
wrdata op_288.txt i(vsupply0) v(xcase0.att_n0) v(xcase0.att_n1) v(xcase0.att_n2) v(xcase0.att_p0) v(xcase0.att_p1) v(xcase0.att_p2) v(cctrl0) v(cm0) v(xcase0.inn) v(xcase0.inp) v(inx0) v(iny0) v(xcase0.nbias) v(outn0) v(outp0) v(xcase0.p_bias) v(xcase0.rc_ct) v(xcase0.rc_gate) v(xcase0.rc_mid) v(rctrl0) v(xcase0.s1) v(xcase0.s2) v(vdd0) i(vsupply81) v(xcase81.att_n0) v(xcase81.att_n1) v(xcase81.att_n2) v(xcase81.att_p0) v(xcase81.att_p1) v(xcase81.att_p2) v(cctrl81) v(cm81) v(xcase81.inn) v(xcase81.inp) v(inx81) v(iny81) v(xcase81.nbias) v(outn81) v(outp81) v(xcase81.p_bias) v(rctrl81) v(xcase81.s1) v(xcase81.s2) v(vdd81)
ac dec 50 1meg 100g
wrdata ac_288.txt v(outp0) v(outn0) v(vid0) v(outp81) v(outn81) v(vid81)
alter Vr0 1.404
alter Vc0 0.432
op
wrdata op_289.txt i(vsupply0) v(xcase0.att_n0) v(xcase0.att_n1) v(xcase0.att_n2) v(xcase0.att_p0) v(xcase0.att_p1) v(xcase0.att_p2) v(cctrl0) v(cm0) v(xcase0.inn) v(xcase0.inp) v(inx0) v(iny0) v(xcase0.nbias) v(outn0) v(outp0) v(xcase0.p_bias) v(xcase0.rc_ct) v(xcase0.rc_gate) v(xcase0.rc_mid) v(rctrl0) v(xcase0.s1) v(xcase0.s2) v(vdd0) i(vsupply81) v(xcase81.att_n0) v(xcase81.att_n1) v(xcase81.att_n2) v(xcase81.att_p0) v(xcase81.att_p1) v(xcase81.att_p2) v(cctrl81) v(cm81) v(xcase81.inn) v(xcase81.inp) v(inx81) v(iny81) v(xcase81.nbias) v(outn81) v(outp81) v(xcase81.p_bias) v(rctrl81) v(xcase81.s1) v(xcase81.s2) v(vdd81)
ac dec 50 1meg 100g
wrdata ac_289.txt v(outp0) v(outn0) v(vid0) v(outp81) v(outn81) v(vid81)
alter Vr0 1.404
alter Vc0 0.459
op
wrdata op_290.txt i(vsupply0) v(xcase0.att_n0) v(xcase0.att_n1) v(xcase0.att_n2) v(xcase0.att_p0) v(xcase0.att_p1) v(xcase0.att_p2) v(cctrl0) v(cm0) v(xcase0.inn) v(xcase0.inp) v(inx0) v(iny0) v(xcase0.nbias) v(outn0) v(outp0) v(xcase0.p_bias) v(xcase0.rc_ct) v(xcase0.rc_gate) v(xcase0.rc_mid) v(rctrl0) v(xcase0.s1) v(xcase0.s2) v(vdd0) i(vsupply81) v(xcase81.att_n0) v(xcase81.att_n1) v(xcase81.att_n2) v(xcase81.att_p0) v(xcase81.att_p1) v(xcase81.att_p2) v(cctrl81) v(cm81) v(xcase81.inn) v(xcase81.inp) v(inx81) v(iny81) v(xcase81.nbias) v(outn81) v(outp81) v(xcase81.p_bias) v(rctrl81) v(xcase81.s1) v(xcase81.s2) v(vdd81)
ac dec 50 1meg 100g
wrdata ac_290.txt v(outp0) v(outn0) v(vid0) v(outp81) v(outn81) v(vid81)
alter Vr0 1.404
alter Vc0 0.486
op
wrdata op_291.txt i(vsupply0) v(xcase0.att_n0) v(xcase0.att_n1) v(xcase0.att_n2) v(xcase0.att_p0) v(xcase0.att_p1) v(xcase0.att_p2) v(cctrl0) v(cm0) v(xcase0.inn) v(xcase0.inp) v(inx0) v(iny0) v(xcase0.nbias) v(outn0) v(outp0) v(xcase0.p_bias) v(xcase0.rc_ct) v(xcase0.rc_gate) v(xcase0.rc_mid) v(rctrl0) v(xcase0.s1) v(xcase0.s2) v(vdd0) i(vsupply81) v(xcase81.att_n0) v(xcase81.att_n1) v(xcase81.att_n2) v(xcase81.att_p0) v(xcase81.att_p1) v(xcase81.att_p2) v(cctrl81) v(cm81) v(xcase81.inn) v(xcase81.inp) v(inx81) v(iny81) v(xcase81.nbias) v(outn81) v(outp81) v(xcase81.p_bias) v(rctrl81) v(xcase81.s1) v(xcase81.s2) v(vdd81)
ac dec 50 1meg 100g
wrdata ac_291.txt v(outp0) v(outn0) v(vid0) v(outp81) v(outn81) v(vid81)
alter Vr0 1.404
alter Vc0 0.513
op
wrdata op_292.txt i(vsupply0) v(xcase0.att_n0) v(xcase0.att_n1) v(xcase0.att_n2) v(xcase0.att_p0) v(xcase0.att_p1) v(xcase0.att_p2) v(cctrl0) v(cm0) v(xcase0.inn) v(xcase0.inp) v(inx0) v(iny0) v(xcase0.nbias) v(outn0) v(outp0) v(xcase0.p_bias) v(xcase0.rc_ct) v(xcase0.rc_gate) v(xcase0.rc_mid) v(rctrl0) v(xcase0.s1) v(xcase0.s2) v(vdd0) i(vsupply81) v(xcase81.att_n0) v(xcase81.att_n1) v(xcase81.att_n2) v(xcase81.att_p0) v(xcase81.att_p1) v(xcase81.att_p2) v(cctrl81) v(cm81) v(xcase81.inn) v(xcase81.inp) v(inx81) v(iny81) v(xcase81.nbias) v(outn81) v(outp81) v(xcase81.p_bias) v(rctrl81) v(xcase81.s1) v(xcase81.s2) v(vdd81)
ac dec 50 1meg 100g
wrdata ac_292.txt v(outp0) v(outn0) v(vid0) v(outp81) v(outn81) v(vid81)
alter Vr0 1.404
alter Vc0 0.54
op
wrdata op_293.txt i(vsupply0) v(xcase0.att_n0) v(xcase0.att_n1) v(xcase0.att_n2) v(xcase0.att_p0) v(xcase0.att_p1) v(xcase0.att_p2) v(cctrl0) v(cm0) v(xcase0.inn) v(xcase0.inp) v(inx0) v(iny0) v(xcase0.nbias) v(outn0) v(outp0) v(xcase0.p_bias) v(xcase0.rc_ct) v(xcase0.rc_gate) v(xcase0.rc_mid) v(rctrl0) v(xcase0.s1) v(xcase0.s2) v(vdd0) i(vsupply81) v(xcase81.att_n0) v(xcase81.att_n1) v(xcase81.att_n2) v(xcase81.att_p0) v(xcase81.att_p1) v(xcase81.att_p2) v(cctrl81) v(cm81) v(xcase81.inn) v(xcase81.inp) v(inx81) v(iny81) v(xcase81.nbias) v(outn81) v(outp81) v(xcase81.p_bias) v(rctrl81) v(xcase81.s1) v(xcase81.s2) v(vdd81)
ac dec 50 1meg 100g
wrdata ac_293.txt v(outp0) v(outn0) v(vid0) v(outp81) v(outn81) v(vid81)
alter Vr0 1.422
alter Vc0 0
op
wrdata op_294.txt i(vsupply0) v(xcase0.att_n0) v(xcase0.att_n1) v(xcase0.att_n2) v(xcase0.att_p0) v(xcase0.att_p1) v(xcase0.att_p2) v(cctrl0) v(cm0) v(xcase0.inn) v(xcase0.inp) v(inx0) v(iny0) v(xcase0.nbias) v(outn0) v(outp0) v(xcase0.p_bias) v(xcase0.rc_ct) v(xcase0.rc_gate) v(xcase0.rc_mid) v(rctrl0) v(xcase0.s1) v(xcase0.s2) v(vdd0) i(vsupply81) v(xcase81.att_n0) v(xcase81.att_n1) v(xcase81.att_n2) v(xcase81.att_p0) v(xcase81.att_p1) v(xcase81.att_p2) v(cctrl81) v(cm81) v(xcase81.inn) v(xcase81.inp) v(inx81) v(iny81) v(xcase81.nbias) v(outn81) v(outp81) v(xcase81.p_bias) v(rctrl81) v(xcase81.s1) v(xcase81.s2) v(vdd81)
ac dec 50 1meg 100g
wrdata ac_294.txt v(outp0) v(outn0) v(vid0) v(outp81) v(outn81) v(vid81)
alter Vr0 1.422
alter Vc0 0.027
op
wrdata op_295.txt i(vsupply0) v(xcase0.att_n0) v(xcase0.att_n1) v(xcase0.att_n2) v(xcase0.att_p0) v(xcase0.att_p1) v(xcase0.att_p2) v(cctrl0) v(cm0) v(xcase0.inn) v(xcase0.inp) v(inx0) v(iny0) v(xcase0.nbias) v(outn0) v(outp0) v(xcase0.p_bias) v(xcase0.rc_ct) v(xcase0.rc_gate) v(xcase0.rc_mid) v(rctrl0) v(xcase0.s1) v(xcase0.s2) v(vdd0) i(vsupply81) v(xcase81.att_n0) v(xcase81.att_n1) v(xcase81.att_n2) v(xcase81.att_p0) v(xcase81.att_p1) v(xcase81.att_p2) v(cctrl81) v(cm81) v(xcase81.inn) v(xcase81.inp) v(inx81) v(iny81) v(xcase81.nbias) v(outn81) v(outp81) v(xcase81.p_bias) v(rctrl81) v(xcase81.s1) v(xcase81.s2) v(vdd81)
ac dec 50 1meg 100g
wrdata ac_295.txt v(outp0) v(outn0) v(vid0) v(outp81) v(outn81) v(vid81)
alter Vr0 1.422
alter Vc0 0.054
op
wrdata op_296.txt i(vsupply0) v(xcase0.att_n0) v(xcase0.att_n1) v(xcase0.att_n2) v(xcase0.att_p0) v(xcase0.att_p1) v(xcase0.att_p2) v(cctrl0) v(cm0) v(xcase0.inn) v(xcase0.inp) v(inx0) v(iny0) v(xcase0.nbias) v(outn0) v(outp0) v(xcase0.p_bias) v(xcase0.rc_ct) v(xcase0.rc_gate) v(xcase0.rc_mid) v(rctrl0) v(xcase0.s1) v(xcase0.s2) v(vdd0) i(vsupply81) v(xcase81.att_n0) v(xcase81.att_n1) v(xcase81.att_n2) v(xcase81.att_p0) v(xcase81.att_p1) v(xcase81.att_p2) v(cctrl81) v(cm81) v(xcase81.inn) v(xcase81.inp) v(inx81) v(iny81) v(xcase81.nbias) v(outn81) v(outp81) v(xcase81.p_bias) v(rctrl81) v(xcase81.s1) v(xcase81.s2) v(vdd81)
ac dec 50 1meg 100g
wrdata ac_296.txt v(outp0) v(outn0) v(vid0) v(outp81) v(outn81) v(vid81)
alter Vr0 1.422
alter Vc0 0.081
op
wrdata op_297.txt i(vsupply0) v(xcase0.att_n0) v(xcase0.att_n1) v(xcase0.att_n2) v(xcase0.att_p0) v(xcase0.att_p1) v(xcase0.att_p2) v(cctrl0) v(cm0) v(xcase0.inn) v(xcase0.inp) v(inx0) v(iny0) v(xcase0.nbias) v(outn0) v(outp0) v(xcase0.p_bias) v(xcase0.rc_ct) v(xcase0.rc_gate) v(xcase0.rc_mid) v(rctrl0) v(xcase0.s1) v(xcase0.s2) v(vdd0) i(vsupply81) v(xcase81.att_n0) v(xcase81.att_n1) v(xcase81.att_n2) v(xcase81.att_p0) v(xcase81.att_p1) v(xcase81.att_p2) v(cctrl81) v(cm81) v(xcase81.inn) v(xcase81.inp) v(inx81) v(iny81) v(xcase81.nbias) v(outn81) v(outp81) v(xcase81.p_bias) v(rctrl81) v(xcase81.s1) v(xcase81.s2) v(vdd81)
ac dec 50 1meg 100g
wrdata ac_297.txt v(outp0) v(outn0) v(vid0) v(outp81) v(outn81) v(vid81)
alter Vr0 1.422
alter Vc0 0.108
op
wrdata op_298.txt i(vsupply0) v(xcase0.att_n0) v(xcase0.att_n1) v(xcase0.att_n2) v(xcase0.att_p0) v(xcase0.att_p1) v(xcase0.att_p2) v(cctrl0) v(cm0) v(xcase0.inn) v(xcase0.inp) v(inx0) v(iny0) v(xcase0.nbias) v(outn0) v(outp0) v(xcase0.p_bias) v(xcase0.rc_ct) v(xcase0.rc_gate) v(xcase0.rc_mid) v(rctrl0) v(xcase0.s1) v(xcase0.s2) v(vdd0) i(vsupply81) v(xcase81.att_n0) v(xcase81.att_n1) v(xcase81.att_n2) v(xcase81.att_p0) v(xcase81.att_p1) v(xcase81.att_p2) v(cctrl81) v(cm81) v(xcase81.inn) v(xcase81.inp) v(inx81) v(iny81) v(xcase81.nbias) v(outn81) v(outp81) v(xcase81.p_bias) v(rctrl81) v(xcase81.s1) v(xcase81.s2) v(vdd81)
ac dec 50 1meg 100g
wrdata ac_298.txt v(outp0) v(outn0) v(vid0) v(outp81) v(outn81) v(vid81)
alter Vr0 1.422
alter Vc0 0.135
op
wrdata op_299.txt i(vsupply0) v(xcase0.att_n0) v(xcase0.att_n1) v(xcase0.att_n2) v(xcase0.att_p0) v(xcase0.att_p1) v(xcase0.att_p2) v(cctrl0) v(cm0) v(xcase0.inn) v(xcase0.inp) v(inx0) v(iny0) v(xcase0.nbias) v(outn0) v(outp0) v(xcase0.p_bias) v(xcase0.rc_ct) v(xcase0.rc_gate) v(xcase0.rc_mid) v(rctrl0) v(xcase0.s1) v(xcase0.s2) v(vdd0) i(vsupply81) v(xcase81.att_n0) v(xcase81.att_n1) v(xcase81.att_n2) v(xcase81.att_p0) v(xcase81.att_p1) v(xcase81.att_p2) v(cctrl81) v(cm81) v(xcase81.inn) v(xcase81.inp) v(inx81) v(iny81) v(xcase81.nbias) v(outn81) v(outp81) v(xcase81.p_bias) v(rctrl81) v(xcase81.s1) v(xcase81.s2) v(vdd81)
ac dec 50 1meg 100g
wrdata ac_299.txt v(outp0) v(outn0) v(vid0) v(outp81) v(outn81) v(vid81)
alter Vr0 1.422
alter Vc0 0.162
op
wrdata op_300.txt i(vsupply0) v(xcase0.att_n0) v(xcase0.att_n1) v(xcase0.att_n2) v(xcase0.att_p0) v(xcase0.att_p1) v(xcase0.att_p2) v(cctrl0) v(cm0) v(xcase0.inn) v(xcase0.inp) v(inx0) v(iny0) v(xcase0.nbias) v(outn0) v(outp0) v(xcase0.p_bias) v(xcase0.rc_ct) v(xcase0.rc_gate) v(xcase0.rc_mid) v(rctrl0) v(xcase0.s1) v(xcase0.s2) v(vdd0) i(vsupply81) v(xcase81.att_n0) v(xcase81.att_n1) v(xcase81.att_n2) v(xcase81.att_p0) v(xcase81.att_p1) v(xcase81.att_p2) v(cctrl81) v(cm81) v(xcase81.inn) v(xcase81.inp) v(inx81) v(iny81) v(xcase81.nbias) v(outn81) v(outp81) v(xcase81.p_bias) v(rctrl81) v(xcase81.s1) v(xcase81.s2) v(vdd81)
ac dec 50 1meg 100g
wrdata ac_300.txt v(outp0) v(outn0) v(vid0) v(outp81) v(outn81) v(vid81)
alter Vr0 1.422
alter Vc0 0.189
op
wrdata op_301.txt i(vsupply0) v(xcase0.att_n0) v(xcase0.att_n1) v(xcase0.att_n2) v(xcase0.att_p0) v(xcase0.att_p1) v(xcase0.att_p2) v(cctrl0) v(cm0) v(xcase0.inn) v(xcase0.inp) v(inx0) v(iny0) v(xcase0.nbias) v(outn0) v(outp0) v(xcase0.p_bias) v(xcase0.rc_ct) v(xcase0.rc_gate) v(xcase0.rc_mid) v(rctrl0) v(xcase0.s1) v(xcase0.s2) v(vdd0) i(vsupply81) v(xcase81.att_n0) v(xcase81.att_n1) v(xcase81.att_n2) v(xcase81.att_p0) v(xcase81.att_p1) v(xcase81.att_p2) v(cctrl81) v(cm81) v(xcase81.inn) v(xcase81.inp) v(inx81) v(iny81) v(xcase81.nbias) v(outn81) v(outp81) v(xcase81.p_bias) v(rctrl81) v(xcase81.s1) v(xcase81.s2) v(vdd81)
ac dec 50 1meg 100g
wrdata ac_301.txt v(outp0) v(outn0) v(vid0) v(outp81) v(outn81) v(vid81)
alter Vr0 1.422
alter Vc0 0.216
op
wrdata op_302.txt i(vsupply0) v(xcase0.att_n0) v(xcase0.att_n1) v(xcase0.att_n2) v(xcase0.att_p0) v(xcase0.att_p1) v(xcase0.att_p2) v(cctrl0) v(cm0) v(xcase0.inn) v(xcase0.inp) v(inx0) v(iny0) v(xcase0.nbias) v(outn0) v(outp0) v(xcase0.p_bias) v(xcase0.rc_ct) v(xcase0.rc_gate) v(xcase0.rc_mid) v(rctrl0) v(xcase0.s1) v(xcase0.s2) v(vdd0) i(vsupply81) v(xcase81.att_n0) v(xcase81.att_n1) v(xcase81.att_n2) v(xcase81.att_p0) v(xcase81.att_p1) v(xcase81.att_p2) v(cctrl81) v(cm81) v(xcase81.inn) v(xcase81.inp) v(inx81) v(iny81) v(xcase81.nbias) v(outn81) v(outp81) v(xcase81.p_bias) v(rctrl81) v(xcase81.s1) v(xcase81.s2) v(vdd81)
ac dec 50 1meg 100g
wrdata ac_302.txt v(outp0) v(outn0) v(vid0) v(outp81) v(outn81) v(vid81)
alter Vr0 1.422
alter Vc0 0.243
op
wrdata op_303.txt i(vsupply0) v(xcase0.att_n0) v(xcase0.att_n1) v(xcase0.att_n2) v(xcase0.att_p0) v(xcase0.att_p1) v(xcase0.att_p2) v(cctrl0) v(cm0) v(xcase0.inn) v(xcase0.inp) v(inx0) v(iny0) v(xcase0.nbias) v(outn0) v(outp0) v(xcase0.p_bias) v(xcase0.rc_ct) v(xcase0.rc_gate) v(xcase0.rc_mid) v(rctrl0) v(xcase0.s1) v(xcase0.s2) v(vdd0) i(vsupply81) v(xcase81.att_n0) v(xcase81.att_n1) v(xcase81.att_n2) v(xcase81.att_p0) v(xcase81.att_p1) v(xcase81.att_p2) v(cctrl81) v(cm81) v(xcase81.inn) v(xcase81.inp) v(inx81) v(iny81) v(xcase81.nbias) v(outn81) v(outp81) v(xcase81.p_bias) v(rctrl81) v(xcase81.s1) v(xcase81.s2) v(vdd81)
ac dec 50 1meg 100g
wrdata ac_303.txt v(outp0) v(outn0) v(vid0) v(outp81) v(outn81) v(vid81)
alter Vr0 1.422
alter Vc0 0.27
op
wrdata op_304.txt i(vsupply0) v(xcase0.att_n0) v(xcase0.att_n1) v(xcase0.att_n2) v(xcase0.att_p0) v(xcase0.att_p1) v(xcase0.att_p2) v(cctrl0) v(cm0) v(xcase0.inn) v(xcase0.inp) v(inx0) v(iny0) v(xcase0.nbias) v(outn0) v(outp0) v(xcase0.p_bias) v(xcase0.rc_ct) v(xcase0.rc_gate) v(xcase0.rc_mid) v(rctrl0) v(xcase0.s1) v(xcase0.s2) v(vdd0) i(vsupply81) v(xcase81.att_n0) v(xcase81.att_n1) v(xcase81.att_n2) v(xcase81.att_p0) v(xcase81.att_p1) v(xcase81.att_p2) v(cctrl81) v(cm81) v(xcase81.inn) v(xcase81.inp) v(inx81) v(iny81) v(xcase81.nbias) v(outn81) v(outp81) v(xcase81.p_bias) v(rctrl81) v(xcase81.s1) v(xcase81.s2) v(vdd81)
ac dec 50 1meg 100g
wrdata ac_304.txt v(outp0) v(outn0) v(vid0) v(outp81) v(outn81) v(vid81)
alter Vr0 1.422
alter Vc0 0.297
op
wrdata op_305.txt i(vsupply0) v(xcase0.att_n0) v(xcase0.att_n1) v(xcase0.att_n2) v(xcase0.att_p0) v(xcase0.att_p1) v(xcase0.att_p2) v(cctrl0) v(cm0) v(xcase0.inn) v(xcase0.inp) v(inx0) v(iny0) v(xcase0.nbias) v(outn0) v(outp0) v(xcase0.p_bias) v(xcase0.rc_ct) v(xcase0.rc_gate) v(xcase0.rc_mid) v(rctrl0) v(xcase0.s1) v(xcase0.s2) v(vdd0) i(vsupply81) v(xcase81.att_n0) v(xcase81.att_n1) v(xcase81.att_n2) v(xcase81.att_p0) v(xcase81.att_p1) v(xcase81.att_p2) v(cctrl81) v(cm81) v(xcase81.inn) v(xcase81.inp) v(inx81) v(iny81) v(xcase81.nbias) v(outn81) v(outp81) v(xcase81.p_bias) v(rctrl81) v(xcase81.s1) v(xcase81.s2) v(vdd81)
ac dec 50 1meg 100g
wrdata ac_305.txt v(outp0) v(outn0) v(vid0) v(outp81) v(outn81) v(vid81)
alter Vr0 1.422
alter Vc0 0.324
op
wrdata op_306.txt i(vsupply0) v(xcase0.att_n0) v(xcase0.att_n1) v(xcase0.att_n2) v(xcase0.att_p0) v(xcase0.att_p1) v(xcase0.att_p2) v(cctrl0) v(cm0) v(xcase0.inn) v(xcase0.inp) v(inx0) v(iny0) v(xcase0.nbias) v(outn0) v(outp0) v(xcase0.p_bias) v(xcase0.rc_ct) v(xcase0.rc_gate) v(xcase0.rc_mid) v(rctrl0) v(xcase0.s1) v(xcase0.s2) v(vdd0) i(vsupply81) v(xcase81.att_n0) v(xcase81.att_n1) v(xcase81.att_n2) v(xcase81.att_p0) v(xcase81.att_p1) v(xcase81.att_p2) v(cctrl81) v(cm81) v(xcase81.inn) v(xcase81.inp) v(inx81) v(iny81) v(xcase81.nbias) v(outn81) v(outp81) v(xcase81.p_bias) v(rctrl81) v(xcase81.s1) v(xcase81.s2) v(vdd81)
ac dec 50 1meg 100g
wrdata ac_306.txt v(outp0) v(outn0) v(vid0) v(outp81) v(outn81) v(vid81)
alter Vr0 1.422
alter Vc0 0.351
op
wrdata op_307.txt i(vsupply0) v(xcase0.att_n0) v(xcase0.att_n1) v(xcase0.att_n2) v(xcase0.att_p0) v(xcase0.att_p1) v(xcase0.att_p2) v(cctrl0) v(cm0) v(xcase0.inn) v(xcase0.inp) v(inx0) v(iny0) v(xcase0.nbias) v(outn0) v(outp0) v(xcase0.p_bias) v(xcase0.rc_ct) v(xcase0.rc_gate) v(xcase0.rc_mid) v(rctrl0) v(xcase0.s1) v(xcase0.s2) v(vdd0) i(vsupply81) v(xcase81.att_n0) v(xcase81.att_n1) v(xcase81.att_n2) v(xcase81.att_p0) v(xcase81.att_p1) v(xcase81.att_p2) v(cctrl81) v(cm81) v(xcase81.inn) v(xcase81.inp) v(inx81) v(iny81) v(xcase81.nbias) v(outn81) v(outp81) v(xcase81.p_bias) v(rctrl81) v(xcase81.s1) v(xcase81.s2) v(vdd81)
ac dec 50 1meg 100g
wrdata ac_307.txt v(outp0) v(outn0) v(vid0) v(outp81) v(outn81) v(vid81)
alter Vr0 1.422
alter Vc0 0.378
op
wrdata op_308.txt i(vsupply0) v(xcase0.att_n0) v(xcase0.att_n1) v(xcase0.att_n2) v(xcase0.att_p0) v(xcase0.att_p1) v(xcase0.att_p2) v(cctrl0) v(cm0) v(xcase0.inn) v(xcase0.inp) v(inx0) v(iny0) v(xcase0.nbias) v(outn0) v(outp0) v(xcase0.p_bias) v(xcase0.rc_ct) v(xcase0.rc_gate) v(xcase0.rc_mid) v(rctrl0) v(xcase0.s1) v(xcase0.s2) v(vdd0) i(vsupply81) v(xcase81.att_n0) v(xcase81.att_n1) v(xcase81.att_n2) v(xcase81.att_p0) v(xcase81.att_p1) v(xcase81.att_p2) v(cctrl81) v(cm81) v(xcase81.inn) v(xcase81.inp) v(inx81) v(iny81) v(xcase81.nbias) v(outn81) v(outp81) v(xcase81.p_bias) v(rctrl81) v(xcase81.s1) v(xcase81.s2) v(vdd81)
ac dec 50 1meg 100g
wrdata ac_308.txt v(outp0) v(outn0) v(vid0) v(outp81) v(outn81) v(vid81)
alter Vr0 1.422
alter Vc0 0.405
op
wrdata op_309.txt i(vsupply0) v(xcase0.att_n0) v(xcase0.att_n1) v(xcase0.att_n2) v(xcase0.att_p0) v(xcase0.att_p1) v(xcase0.att_p2) v(cctrl0) v(cm0) v(xcase0.inn) v(xcase0.inp) v(inx0) v(iny0) v(xcase0.nbias) v(outn0) v(outp0) v(xcase0.p_bias) v(xcase0.rc_ct) v(xcase0.rc_gate) v(xcase0.rc_mid) v(rctrl0) v(xcase0.s1) v(xcase0.s2) v(vdd0) i(vsupply81) v(xcase81.att_n0) v(xcase81.att_n1) v(xcase81.att_n2) v(xcase81.att_p0) v(xcase81.att_p1) v(xcase81.att_p2) v(cctrl81) v(cm81) v(xcase81.inn) v(xcase81.inp) v(inx81) v(iny81) v(xcase81.nbias) v(outn81) v(outp81) v(xcase81.p_bias) v(rctrl81) v(xcase81.s1) v(xcase81.s2) v(vdd81)
ac dec 50 1meg 100g
wrdata ac_309.txt v(outp0) v(outn0) v(vid0) v(outp81) v(outn81) v(vid81)
alter Vr0 1.422
alter Vc0 0.432
op
wrdata op_310.txt i(vsupply0) v(xcase0.att_n0) v(xcase0.att_n1) v(xcase0.att_n2) v(xcase0.att_p0) v(xcase0.att_p1) v(xcase0.att_p2) v(cctrl0) v(cm0) v(xcase0.inn) v(xcase0.inp) v(inx0) v(iny0) v(xcase0.nbias) v(outn0) v(outp0) v(xcase0.p_bias) v(xcase0.rc_ct) v(xcase0.rc_gate) v(xcase0.rc_mid) v(rctrl0) v(xcase0.s1) v(xcase0.s2) v(vdd0) i(vsupply81) v(xcase81.att_n0) v(xcase81.att_n1) v(xcase81.att_n2) v(xcase81.att_p0) v(xcase81.att_p1) v(xcase81.att_p2) v(cctrl81) v(cm81) v(xcase81.inn) v(xcase81.inp) v(inx81) v(iny81) v(xcase81.nbias) v(outn81) v(outp81) v(xcase81.p_bias) v(rctrl81) v(xcase81.s1) v(xcase81.s2) v(vdd81)
ac dec 50 1meg 100g
wrdata ac_310.txt v(outp0) v(outn0) v(vid0) v(outp81) v(outn81) v(vid81)
alter Vr0 1.422
alter Vc0 0.459
op
wrdata op_311.txt i(vsupply0) v(xcase0.att_n0) v(xcase0.att_n1) v(xcase0.att_n2) v(xcase0.att_p0) v(xcase0.att_p1) v(xcase0.att_p2) v(cctrl0) v(cm0) v(xcase0.inn) v(xcase0.inp) v(inx0) v(iny0) v(xcase0.nbias) v(outn0) v(outp0) v(xcase0.p_bias) v(xcase0.rc_ct) v(xcase0.rc_gate) v(xcase0.rc_mid) v(rctrl0) v(xcase0.s1) v(xcase0.s2) v(vdd0) i(vsupply81) v(xcase81.att_n0) v(xcase81.att_n1) v(xcase81.att_n2) v(xcase81.att_p0) v(xcase81.att_p1) v(xcase81.att_p2) v(cctrl81) v(cm81) v(xcase81.inn) v(xcase81.inp) v(inx81) v(iny81) v(xcase81.nbias) v(outn81) v(outp81) v(xcase81.p_bias) v(rctrl81) v(xcase81.s1) v(xcase81.s2) v(vdd81)
ac dec 50 1meg 100g
wrdata ac_311.txt v(outp0) v(outn0) v(vid0) v(outp81) v(outn81) v(vid81)
alter Vr0 1.422
alter Vc0 0.486
op
wrdata op_312.txt i(vsupply0) v(xcase0.att_n0) v(xcase0.att_n1) v(xcase0.att_n2) v(xcase0.att_p0) v(xcase0.att_p1) v(xcase0.att_p2) v(cctrl0) v(cm0) v(xcase0.inn) v(xcase0.inp) v(inx0) v(iny0) v(xcase0.nbias) v(outn0) v(outp0) v(xcase0.p_bias) v(xcase0.rc_ct) v(xcase0.rc_gate) v(xcase0.rc_mid) v(rctrl0) v(xcase0.s1) v(xcase0.s2) v(vdd0) i(vsupply81) v(xcase81.att_n0) v(xcase81.att_n1) v(xcase81.att_n2) v(xcase81.att_p0) v(xcase81.att_p1) v(xcase81.att_p2) v(cctrl81) v(cm81) v(xcase81.inn) v(xcase81.inp) v(inx81) v(iny81) v(xcase81.nbias) v(outn81) v(outp81) v(xcase81.p_bias) v(rctrl81) v(xcase81.s1) v(xcase81.s2) v(vdd81)
ac dec 50 1meg 100g
wrdata ac_312.txt v(outp0) v(outn0) v(vid0) v(outp81) v(outn81) v(vid81)
alter Vr0 1.422
alter Vc0 0.513
op
wrdata op_313.txt i(vsupply0) v(xcase0.att_n0) v(xcase0.att_n1) v(xcase0.att_n2) v(xcase0.att_p0) v(xcase0.att_p1) v(xcase0.att_p2) v(cctrl0) v(cm0) v(xcase0.inn) v(xcase0.inp) v(inx0) v(iny0) v(xcase0.nbias) v(outn0) v(outp0) v(xcase0.p_bias) v(xcase0.rc_ct) v(xcase0.rc_gate) v(xcase0.rc_mid) v(rctrl0) v(xcase0.s1) v(xcase0.s2) v(vdd0) i(vsupply81) v(xcase81.att_n0) v(xcase81.att_n1) v(xcase81.att_n2) v(xcase81.att_p0) v(xcase81.att_p1) v(xcase81.att_p2) v(cctrl81) v(cm81) v(xcase81.inn) v(xcase81.inp) v(inx81) v(iny81) v(xcase81.nbias) v(outn81) v(outp81) v(xcase81.p_bias) v(rctrl81) v(xcase81.s1) v(xcase81.s2) v(vdd81)
ac dec 50 1meg 100g
wrdata ac_313.txt v(outp0) v(outn0) v(vid0) v(outp81) v(outn81) v(vid81)
alter Vr0 1.422
alter Vc0 0.54
op
wrdata op_314.txt i(vsupply0) v(xcase0.att_n0) v(xcase0.att_n1) v(xcase0.att_n2) v(xcase0.att_p0) v(xcase0.att_p1) v(xcase0.att_p2) v(cctrl0) v(cm0) v(xcase0.inn) v(xcase0.inp) v(inx0) v(iny0) v(xcase0.nbias) v(outn0) v(outp0) v(xcase0.p_bias) v(xcase0.rc_ct) v(xcase0.rc_gate) v(xcase0.rc_mid) v(rctrl0) v(xcase0.s1) v(xcase0.s2) v(vdd0) i(vsupply81) v(xcase81.att_n0) v(xcase81.att_n1) v(xcase81.att_n2) v(xcase81.att_p0) v(xcase81.att_p1) v(xcase81.att_p2) v(cctrl81) v(cm81) v(xcase81.inn) v(xcase81.inp) v(inx81) v(iny81) v(xcase81.nbias) v(outn81) v(outp81) v(xcase81.p_bias) v(rctrl81) v(xcase81.s1) v(xcase81.s2) v(vdd81)
ac dec 50 1meg 100g
wrdata ac_314.txt v(outp0) v(outn0) v(vid0) v(outp81) v(outn81) v(vid81)
alter Vr0 1.44
alter Vc0 0
op
wrdata op_315.txt i(vsupply0) v(xcase0.att_n0) v(xcase0.att_n1) v(xcase0.att_n2) v(xcase0.att_p0) v(xcase0.att_p1) v(xcase0.att_p2) v(cctrl0) v(cm0) v(xcase0.inn) v(xcase0.inp) v(inx0) v(iny0) v(xcase0.nbias) v(outn0) v(outp0) v(xcase0.p_bias) v(xcase0.rc_ct) v(xcase0.rc_gate) v(xcase0.rc_mid) v(rctrl0) v(xcase0.s1) v(xcase0.s2) v(vdd0) i(vsupply81) v(xcase81.att_n0) v(xcase81.att_n1) v(xcase81.att_n2) v(xcase81.att_p0) v(xcase81.att_p1) v(xcase81.att_p2) v(cctrl81) v(cm81) v(xcase81.inn) v(xcase81.inp) v(inx81) v(iny81) v(xcase81.nbias) v(outn81) v(outp81) v(xcase81.p_bias) v(rctrl81) v(xcase81.s1) v(xcase81.s2) v(vdd81)
ac dec 50 1meg 100g
wrdata ac_315.txt v(outp0) v(outn0) v(vid0) v(outp81) v(outn81) v(vid81)
alter Vr0 1.44
alter Vc0 0.027
op
wrdata op_316.txt i(vsupply0) v(xcase0.att_n0) v(xcase0.att_n1) v(xcase0.att_n2) v(xcase0.att_p0) v(xcase0.att_p1) v(xcase0.att_p2) v(cctrl0) v(cm0) v(xcase0.inn) v(xcase0.inp) v(inx0) v(iny0) v(xcase0.nbias) v(outn0) v(outp0) v(xcase0.p_bias) v(xcase0.rc_ct) v(xcase0.rc_gate) v(xcase0.rc_mid) v(rctrl0) v(xcase0.s1) v(xcase0.s2) v(vdd0) i(vsupply81) v(xcase81.att_n0) v(xcase81.att_n1) v(xcase81.att_n2) v(xcase81.att_p0) v(xcase81.att_p1) v(xcase81.att_p2) v(cctrl81) v(cm81) v(xcase81.inn) v(xcase81.inp) v(inx81) v(iny81) v(xcase81.nbias) v(outn81) v(outp81) v(xcase81.p_bias) v(rctrl81) v(xcase81.s1) v(xcase81.s2) v(vdd81)
ac dec 50 1meg 100g
wrdata ac_316.txt v(outp0) v(outn0) v(vid0) v(outp81) v(outn81) v(vid81)
alter Vr0 1.44
alter Vc0 0.054
op
wrdata op_317.txt i(vsupply0) v(xcase0.att_n0) v(xcase0.att_n1) v(xcase0.att_n2) v(xcase0.att_p0) v(xcase0.att_p1) v(xcase0.att_p2) v(cctrl0) v(cm0) v(xcase0.inn) v(xcase0.inp) v(inx0) v(iny0) v(xcase0.nbias) v(outn0) v(outp0) v(xcase0.p_bias) v(xcase0.rc_ct) v(xcase0.rc_gate) v(xcase0.rc_mid) v(rctrl0) v(xcase0.s1) v(xcase0.s2) v(vdd0) i(vsupply81) v(xcase81.att_n0) v(xcase81.att_n1) v(xcase81.att_n2) v(xcase81.att_p0) v(xcase81.att_p1) v(xcase81.att_p2) v(cctrl81) v(cm81) v(xcase81.inn) v(xcase81.inp) v(inx81) v(iny81) v(xcase81.nbias) v(outn81) v(outp81) v(xcase81.p_bias) v(rctrl81) v(xcase81.s1) v(xcase81.s2) v(vdd81)
ac dec 50 1meg 100g
wrdata ac_317.txt v(outp0) v(outn0) v(vid0) v(outp81) v(outn81) v(vid81)
alter Vr0 1.44
alter Vc0 0.081
op
wrdata op_318.txt i(vsupply0) v(xcase0.att_n0) v(xcase0.att_n1) v(xcase0.att_n2) v(xcase0.att_p0) v(xcase0.att_p1) v(xcase0.att_p2) v(cctrl0) v(cm0) v(xcase0.inn) v(xcase0.inp) v(inx0) v(iny0) v(xcase0.nbias) v(outn0) v(outp0) v(xcase0.p_bias) v(xcase0.rc_ct) v(xcase0.rc_gate) v(xcase0.rc_mid) v(rctrl0) v(xcase0.s1) v(xcase0.s2) v(vdd0) i(vsupply81) v(xcase81.att_n0) v(xcase81.att_n1) v(xcase81.att_n2) v(xcase81.att_p0) v(xcase81.att_p1) v(xcase81.att_p2) v(cctrl81) v(cm81) v(xcase81.inn) v(xcase81.inp) v(inx81) v(iny81) v(xcase81.nbias) v(outn81) v(outp81) v(xcase81.p_bias) v(rctrl81) v(xcase81.s1) v(xcase81.s2) v(vdd81)
ac dec 50 1meg 100g
wrdata ac_318.txt v(outp0) v(outn0) v(vid0) v(outp81) v(outn81) v(vid81)
alter Vr0 1.44
alter Vc0 0.108
op
wrdata op_319.txt i(vsupply0) v(xcase0.att_n0) v(xcase0.att_n1) v(xcase0.att_n2) v(xcase0.att_p0) v(xcase0.att_p1) v(xcase0.att_p2) v(cctrl0) v(cm0) v(xcase0.inn) v(xcase0.inp) v(inx0) v(iny0) v(xcase0.nbias) v(outn0) v(outp0) v(xcase0.p_bias) v(xcase0.rc_ct) v(xcase0.rc_gate) v(xcase0.rc_mid) v(rctrl0) v(xcase0.s1) v(xcase0.s2) v(vdd0) i(vsupply81) v(xcase81.att_n0) v(xcase81.att_n1) v(xcase81.att_n2) v(xcase81.att_p0) v(xcase81.att_p1) v(xcase81.att_p2) v(cctrl81) v(cm81) v(xcase81.inn) v(xcase81.inp) v(inx81) v(iny81) v(xcase81.nbias) v(outn81) v(outp81) v(xcase81.p_bias) v(rctrl81) v(xcase81.s1) v(xcase81.s2) v(vdd81)
ac dec 50 1meg 100g
wrdata ac_319.txt v(outp0) v(outn0) v(vid0) v(outp81) v(outn81) v(vid81)
alter Vr0 1.44
alter Vc0 0.135
op
wrdata op_320.txt i(vsupply0) v(xcase0.att_n0) v(xcase0.att_n1) v(xcase0.att_n2) v(xcase0.att_p0) v(xcase0.att_p1) v(xcase0.att_p2) v(cctrl0) v(cm0) v(xcase0.inn) v(xcase0.inp) v(inx0) v(iny0) v(xcase0.nbias) v(outn0) v(outp0) v(xcase0.p_bias) v(xcase0.rc_ct) v(xcase0.rc_gate) v(xcase0.rc_mid) v(rctrl0) v(xcase0.s1) v(xcase0.s2) v(vdd0) i(vsupply81) v(xcase81.att_n0) v(xcase81.att_n1) v(xcase81.att_n2) v(xcase81.att_p0) v(xcase81.att_p1) v(xcase81.att_p2) v(cctrl81) v(cm81) v(xcase81.inn) v(xcase81.inp) v(inx81) v(iny81) v(xcase81.nbias) v(outn81) v(outp81) v(xcase81.p_bias) v(rctrl81) v(xcase81.s1) v(xcase81.s2) v(vdd81)
ac dec 50 1meg 100g
wrdata ac_320.txt v(outp0) v(outn0) v(vid0) v(outp81) v(outn81) v(vid81)
alter Vr0 1.44
alter Vc0 0.162
op
wrdata op_321.txt i(vsupply0) v(xcase0.att_n0) v(xcase0.att_n1) v(xcase0.att_n2) v(xcase0.att_p0) v(xcase0.att_p1) v(xcase0.att_p2) v(cctrl0) v(cm0) v(xcase0.inn) v(xcase0.inp) v(inx0) v(iny0) v(xcase0.nbias) v(outn0) v(outp0) v(xcase0.p_bias) v(xcase0.rc_ct) v(xcase0.rc_gate) v(xcase0.rc_mid) v(rctrl0) v(xcase0.s1) v(xcase0.s2) v(vdd0) i(vsupply81) v(xcase81.att_n0) v(xcase81.att_n1) v(xcase81.att_n2) v(xcase81.att_p0) v(xcase81.att_p1) v(xcase81.att_p2) v(cctrl81) v(cm81) v(xcase81.inn) v(xcase81.inp) v(inx81) v(iny81) v(xcase81.nbias) v(outn81) v(outp81) v(xcase81.p_bias) v(rctrl81) v(xcase81.s1) v(xcase81.s2) v(vdd81)
ac dec 50 1meg 100g
wrdata ac_321.txt v(outp0) v(outn0) v(vid0) v(outp81) v(outn81) v(vid81)
alter Vr0 1.44
alter Vc0 0.189
op
wrdata op_322.txt i(vsupply0) v(xcase0.att_n0) v(xcase0.att_n1) v(xcase0.att_n2) v(xcase0.att_p0) v(xcase0.att_p1) v(xcase0.att_p2) v(cctrl0) v(cm0) v(xcase0.inn) v(xcase0.inp) v(inx0) v(iny0) v(xcase0.nbias) v(outn0) v(outp0) v(xcase0.p_bias) v(xcase0.rc_ct) v(xcase0.rc_gate) v(xcase0.rc_mid) v(rctrl0) v(xcase0.s1) v(xcase0.s2) v(vdd0) i(vsupply81) v(xcase81.att_n0) v(xcase81.att_n1) v(xcase81.att_n2) v(xcase81.att_p0) v(xcase81.att_p1) v(xcase81.att_p2) v(cctrl81) v(cm81) v(xcase81.inn) v(xcase81.inp) v(inx81) v(iny81) v(xcase81.nbias) v(outn81) v(outp81) v(xcase81.p_bias) v(rctrl81) v(xcase81.s1) v(xcase81.s2) v(vdd81)
ac dec 50 1meg 100g
wrdata ac_322.txt v(outp0) v(outn0) v(vid0) v(outp81) v(outn81) v(vid81)
alter Vr0 1.44
alter Vc0 0.216
op
wrdata op_323.txt i(vsupply0) v(xcase0.att_n0) v(xcase0.att_n1) v(xcase0.att_n2) v(xcase0.att_p0) v(xcase0.att_p1) v(xcase0.att_p2) v(cctrl0) v(cm0) v(xcase0.inn) v(xcase0.inp) v(inx0) v(iny0) v(xcase0.nbias) v(outn0) v(outp0) v(xcase0.p_bias) v(xcase0.rc_ct) v(xcase0.rc_gate) v(xcase0.rc_mid) v(rctrl0) v(xcase0.s1) v(xcase0.s2) v(vdd0) i(vsupply81) v(xcase81.att_n0) v(xcase81.att_n1) v(xcase81.att_n2) v(xcase81.att_p0) v(xcase81.att_p1) v(xcase81.att_p2) v(cctrl81) v(cm81) v(xcase81.inn) v(xcase81.inp) v(inx81) v(iny81) v(xcase81.nbias) v(outn81) v(outp81) v(xcase81.p_bias) v(rctrl81) v(xcase81.s1) v(xcase81.s2) v(vdd81)
ac dec 50 1meg 100g
wrdata ac_323.txt v(outp0) v(outn0) v(vid0) v(outp81) v(outn81) v(vid81)
alter Vr0 1.44
alter Vc0 0.243
op
wrdata op_324.txt i(vsupply0) v(xcase0.att_n0) v(xcase0.att_n1) v(xcase0.att_n2) v(xcase0.att_p0) v(xcase0.att_p1) v(xcase0.att_p2) v(cctrl0) v(cm0) v(xcase0.inn) v(xcase0.inp) v(inx0) v(iny0) v(xcase0.nbias) v(outn0) v(outp0) v(xcase0.p_bias) v(xcase0.rc_ct) v(xcase0.rc_gate) v(xcase0.rc_mid) v(rctrl0) v(xcase0.s1) v(xcase0.s2) v(vdd0) i(vsupply81) v(xcase81.att_n0) v(xcase81.att_n1) v(xcase81.att_n2) v(xcase81.att_p0) v(xcase81.att_p1) v(xcase81.att_p2) v(cctrl81) v(cm81) v(xcase81.inn) v(xcase81.inp) v(inx81) v(iny81) v(xcase81.nbias) v(outn81) v(outp81) v(xcase81.p_bias) v(rctrl81) v(xcase81.s1) v(xcase81.s2) v(vdd81)
ac dec 50 1meg 100g
wrdata ac_324.txt v(outp0) v(outn0) v(vid0) v(outp81) v(outn81) v(vid81)
alter Vr0 1.44
alter Vc0 0.27
op
wrdata op_325.txt i(vsupply0) v(xcase0.att_n0) v(xcase0.att_n1) v(xcase0.att_n2) v(xcase0.att_p0) v(xcase0.att_p1) v(xcase0.att_p2) v(cctrl0) v(cm0) v(xcase0.inn) v(xcase0.inp) v(inx0) v(iny0) v(xcase0.nbias) v(outn0) v(outp0) v(xcase0.p_bias) v(xcase0.rc_ct) v(xcase0.rc_gate) v(xcase0.rc_mid) v(rctrl0) v(xcase0.s1) v(xcase0.s2) v(vdd0) i(vsupply81) v(xcase81.att_n0) v(xcase81.att_n1) v(xcase81.att_n2) v(xcase81.att_p0) v(xcase81.att_p1) v(xcase81.att_p2) v(cctrl81) v(cm81) v(xcase81.inn) v(xcase81.inp) v(inx81) v(iny81) v(xcase81.nbias) v(outn81) v(outp81) v(xcase81.p_bias) v(rctrl81) v(xcase81.s1) v(xcase81.s2) v(vdd81)
ac dec 50 1meg 100g
wrdata ac_325.txt v(outp0) v(outn0) v(vid0) v(outp81) v(outn81) v(vid81)
alter Vr0 1.44
alter Vc0 0.297
op
wrdata op_326.txt i(vsupply0) v(xcase0.att_n0) v(xcase0.att_n1) v(xcase0.att_n2) v(xcase0.att_p0) v(xcase0.att_p1) v(xcase0.att_p2) v(cctrl0) v(cm0) v(xcase0.inn) v(xcase0.inp) v(inx0) v(iny0) v(xcase0.nbias) v(outn0) v(outp0) v(xcase0.p_bias) v(xcase0.rc_ct) v(xcase0.rc_gate) v(xcase0.rc_mid) v(rctrl0) v(xcase0.s1) v(xcase0.s2) v(vdd0) i(vsupply81) v(xcase81.att_n0) v(xcase81.att_n1) v(xcase81.att_n2) v(xcase81.att_p0) v(xcase81.att_p1) v(xcase81.att_p2) v(cctrl81) v(cm81) v(xcase81.inn) v(xcase81.inp) v(inx81) v(iny81) v(xcase81.nbias) v(outn81) v(outp81) v(xcase81.p_bias) v(rctrl81) v(xcase81.s1) v(xcase81.s2) v(vdd81)
ac dec 50 1meg 100g
wrdata ac_326.txt v(outp0) v(outn0) v(vid0) v(outp81) v(outn81) v(vid81)
alter Vr0 1.44
alter Vc0 0.324
op
wrdata op_327.txt i(vsupply0) v(xcase0.att_n0) v(xcase0.att_n1) v(xcase0.att_n2) v(xcase0.att_p0) v(xcase0.att_p1) v(xcase0.att_p2) v(cctrl0) v(cm0) v(xcase0.inn) v(xcase0.inp) v(inx0) v(iny0) v(xcase0.nbias) v(outn0) v(outp0) v(xcase0.p_bias) v(xcase0.rc_ct) v(xcase0.rc_gate) v(xcase0.rc_mid) v(rctrl0) v(xcase0.s1) v(xcase0.s2) v(vdd0) i(vsupply81) v(xcase81.att_n0) v(xcase81.att_n1) v(xcase81.att_n2) v(xcase81.att_p0) v(xcase81.att_p1) v(xcase81.att_p2) v(cctrl81) v(cm81) v(xcase81.inn) v(xcase81.inp) v(inx81) v(iny81) v(xcase81.nbias) v(outn81) v(outp81) v(xcase81.p_bias) v(rctrl81) v(xcase81.s1) v(xcase81.s2) v(vdd81)
ac dec 50 1meg 100g
wrdata ac_327.txt v(outp0) v(outn0) v(vid0) v(outp81) v(outn81) v(vid81)
alter Vr0 1.44
alter Vc0 0.351
op
wrdata op_328.txt i(vsupply0) v(xcase0.att_n0) v(xcase0.att_n1) v(xcase0.att_n2) v(xcase0.att_p0) v(xcase0.att_p1) v(xcase0.att_p2) v(cctrl0) v(cm0) v(xcase0.inn) v(xcase0.inp) v(inx0) v(iny0) v(xcase0.nbias) v(outn0) v(outp0) v(xcase0.p_bias) v(xcase0.rc_ct) v(xcase0.rc_gate) v(xcase0.rc_mid) v(rctrl0) v(xcase0.s1) v(xcase0.s2) v(vdd0) i(vsupply81) v(xcase81.att_n0) v(xcase81.att_n1) v(xcase81.att_n2) v(xcase81.att_p0) v(xcase81.att_p1) v(xcase81.att_p2) v(cctrl81) v(cm81) v(xcase81.inn) v(xcase81.inp) v(inx81) v(iny81) v(xcase81.nbias) v(outn81) v(outp81) v(xcase81.p_bias) v(rctrl81) v(xcase81.s1) v(xcase81.s2) v(vdd81)
ac dec 50 1meg 100g
wrdata ac_328.txt v(outp0) v(outn0) v(vid0) v(outp81) v(outn81) v(vid81)
alter Vr0 1.44
alter Vc0 0.378
op
wrdata op_329.txt i(vsupply0) v(xcase0.att_n0) v(xcase0.att_n1) v(xcase0.att_n2) v(xcase0.att_p0) v(xcase0.att_p1) v(xcase0.att_p2) v(cctrl0) v(cm0) v(xcase0.inn) v(xcase0.inp) v(inx0) v(iny0) v(xcase0.nbias) v(outn0) v(outp0) v(xcase0.p_bias) v(xcase0.rc_ct) v(xcase0.rc_gate) v(xcase0.rc_mid) v(rctrl0) v(xcase0.s1) v(xcase0.s2) v(vdd0) i(vsupply81) v(xcase81.att_n0) v(xcase81.att_n1) v(xcase81.att_n2) v(xcase81.att_p0) v(xcase81.att_p1) v(xcase81.att_p2) v(cctrl81) v(cm81) v(xcase81.inn) v(xcase81.inp) v(inx81) v(iny81) v(xcase81.nbias) v(outn81) v(outp81) v(xcase81.p_bias) v(rctrl81) v(xcase81.s1) v(xcase81.s2) v(vdd81)
ac dec 50 1meg 100g
wrdata ac_329.txt v(outp0) v(outn0) v(vid0) v(outp81) v(outn81) v(vid81)
alter Vr0 1.44
alter Vc0 0.405
op
wrdata op_330.txt i(vsupply0) v(xcase0.att_n0) v(xcase0.att_n1) v(xcase0.att_n2) v(xcase0.att_p0) v(xcase0.att_p1) v(xcase0.att_p2) v(cctrl0) v(cm0) v(xcase0.inn) v(xcase0.inp) v(inx0) v(iny0) v(xcase0.nbias) v(outn0) v(outp0) v(xcase0.p_bias) v(xcase0.rc_ct) v(xcase0.rc_gate) v(xcase0.rc_mid) v(rctrl0) v(xcase0.s1) v(xcase0.s2) v(vdd0) i(vsupply81) v(xcase81.att_n0) v(xcase81.att_n1) v(xcase81.att_n2) v(xcase81.att_p0) v(xcase81.att_p1) v(xcase81.att_p2) v(cctrl81) v(cm81) v(xcase81.inn) v(xcase81.inp) v(inx81) v(iny81) v(xcase81.nbias) v(outn81) v(outp81) v(xcase81.p_bias) v(rctrl81) v(xcase81.s1) v(xcase81.s2) v(vdd81)
ac dec 50 1meg 100g
wrdata ac_330.txt v(outp0) v(outn0) v(vid0) v(outp81) v(outn81) v(vid81)
alter Vr0 1.44
alter Vc0 0.432
op
wrdata op_331.txt i(vsupply0) v(xcase0.att_n0) v(xcase0.att_n1) v(xcase0.att_n2) v(xcase0.att_p0) v(xcase0.att_p1) v(xcase0.att_p2) v(cctrl0) v(cm0) v(xcase0.inn) v(xcase0.inp) v(inx0) v(iny0) v(xcase0.nbias) v(outn0) v(outp0) v(xcase0.p_bias) v(xcase0.rc_ct) v(xcase0.rc_gate) v(xcase0.rc_mid) v(rctrl0) v(xcase0.s1) v(xcase0.s2) v(vdd0) i(vsupply81) v(xcase81.att_n0) v(xcase81.att_n1) v(xcase81.att_n2) v(xcase81.att_p0) v(xcase81.att_p1) v(xcase81.att_p2) v(cctrl81) v(cm81) v(xcase81.inn) v(xcase81.inp) v(inx81) v(iny81) v(xcase81.nbias) v(outn81) v(outp81) v(xcase81.p_bias) v(rctrl81) v(xcase81.s1) v(xcase81.s2) v(vdd81)
ac dec 50 1meg 100g
wrdata ac_331.txt v(outp0) v(outn0) v(vid0) v(outp81) v(outn81) v(vid81)
alter Vr0 1.44
alter Vc0 0.459
op
wrdata op_332.txt i(vsupply0) v(xcase0.att_n0) v(xcase0.att_n1) v(xcase0.att_n2) v(xcase0.att_p0) v(xcase0.att_p1) v(xcase0.att_p2) v(cctrl0) v(cm0) v(xcase0.inn) v(xcase0.inp) v(inx0) v(iny0) v(xcase0.nbias) v(outn0) v(outp0) v(xcase0.p_bias) v(xcase0.rc_ct) v(xcase0.rc_gate) v(xcase0.rc_mid) v(rctrl0) v(xcase0.s1) v(xcase0.s2) v(vdd0) i(vsupply81) v(xcase81.att_n0) v(xcase81.att_n1) v(xcase81.att_n2) v(xcase81.att_p0) v(xcase81.att_p1) v(xcase81.att_p2) v(cctrl81) v(cm81) v(xcase81.inn) v(xcase81.inp) v(inx81) v(iny81) v(xcase81.nbias) v(outn81) v(outp81) v(xcase81.p_bias) v(rctrl81) v(xcase81.s1) v(xcase81.s2) v(vdd81)
ac dec 50 1meg 100g
wrdata ac_332.txt v(outp0) v(outn0) v(vid0) v(outp81) v(outn81) v(vid81)
alter Vr0 1.44
alter Vc0 0.486
op
wrdata op_333.txt i(vsupply0) v(xcase0.att_n0) v(xcase0.att_n1) v(xcase0.att_n2) v(xcase0.att_p0) v(xcase0.att_p1) v(xcase0.att_p2) v(cctrl0) v(cm0) v(xcase0.inn) v(xcase0.inp) v(inx0) v(iny0) v(xcase0.nbias) v(outn0) v(outp0) v(xcase0.p_bias) v(xcase0.rc_ct) v(xcase0.rc_gate) v(xcase0.rc_mid) v(rctrl0) v(xcase0.s1) v(xcase0.s2) v(vdd0) i(vsupply81) v(xcase81.att_n0) v(xcase81.att_n1) v(xcase81.att_n2) v(xcase81.att_p0) v(xcase81.att_p1) v(xcase81.att_p2) v(cctrl81) v(cm81) v(xcase81.inn) v(xcase81.inp) v(inx81) v(iny81) v(xcase81.nbias) v(outn81) v(outp81) v(xcase81.p_bias) v(rctrl81) v(xcase81.s1) v(xcase81.s2) v(vdd81)
ac dec 50 1meg 100g
wrdata ac_333.txt v(outp0) v(outn0) v(vid0) v(outp81) v(outn81) v(vid81)
alter Vr0 1.44
alter Vc0 0.513
op
wrdata op_334.txt i(vsupply0) v(xcase0.att_n0) v(xcase0.att_n1) v(xcase0.att_n2) v(xcase0.att_p0) v(xcase0.att_p1) v(xcase0.att_p2) v(cctrl0) v(cm0) v(xcase0.inn) v(xcase0.inp) v(inx0) v(iny0) v(xcase0.nbias) v(outn0) v(outp0) v(xcase0.p_bias) v(xcase0.rc_ct) v(xcase0.rc_gate) v(xcase0.rc_mid) v(rctrl0) v(xcase0.s1) v(xcase0.s2) v(vdd0) i(vsupply81) v(xcase81.att_n0) v(xcase81.att_n1) v(xcase81.att_n2) v(xcase81.att_p0) v(xcase81.att_p1) v(xcase81.att_p2) v(cctrl81) v(cm81) v(xcase81.inn) v(xcase81.inp) v(inx81) v(iny81) v(xcase81.nbias) v(outn81) v(outp81) v(xcase81.p_bias) v(rctrl81) v(xcase81.s1) v(xcase81.s2) v(vdd81)
ac dec 50 1meg 100g
wrdata ac_334.txt v(outp0) v(outn0) v(vid0) v(outp81) v(outn81) v(vid81)
alter Vr0 1.44
alter Vc0 0.54
op
wrdata op_335.txt i(vsupply0) v(xcase0.att_n0) v(xcase0.att_n1) v(xcase0.att_n2) v(xcase0.att_p0) v(xcase0.att_p1) v(xcase0.att_p2) v(cctrl0) v(cm0) v(xcase0.inn) v(xcase0.inp) v(inx0) v(iny0) v(xcase0.nbias) v(outn0) v(outp0) v(xcase0.p_bias) v(xcase0.rc_ct) v(xcase0.rc_gate) v(xcase0.rc_mid) v(rctrl0) v(xcase0.s1) v(xcase0.s2) v(vdd0) i(vsupply81) v(xcase81.att_n0) v(xcase81.att_n1) v(xcase81.att_n2) v(xcase81.att_p0) v(xcase81.att_p1) v(xcase81.att_p2) v(cctrl81) v(cm81) v(xcase81.inn) v(xcase81.inp) v(inx81) v(iny81) v(xcase81.nbias) v(outn81) v(outp81) v(xcase81.p_bias) v(rctrl81) v(xcase81.s1) v(xcase81.s2) v(vdd81)
ac dec 50 1meg 100g
wrdata ac_335.txt v(outp0) v(outn0) v(vid0) v(outp81) v(outn81) v(vid81)
alter Vr0 1.458
alter Vc0 0
op
wrdata op_336.txt i(vsupply0) v(xcase0.att_n0) v(xcase0.att_n1) v(xcase0.att_n2) v(xcase0.att_p0) v(xcase0.att_p1) v(xcase0.att_p2) v(cctrl0) v(cm0) v(xcase0.inn) v(xcase0.inp) v(inx0) v(iny0) v(xcase0.nbias) v(outn0) v(outp0) v(xcase0.p_bias) v(xcase0.rc_ct) v(xcase0.rc_gate) v(xcase0.rc_mid) v(rctrl0) v(xcase0.s1) v(xcase0.s2) v(vdd0) i(vsupply81) v(xcase81.att_n0) v(xcase81.att_n1) v(xcase81.att_n2) v(xcase81.att_p0) v(xcase81.att_p1) v(xcase81.att_p2) v(cctrl81) v(cm81) v(xcase81.inn) v(xcase81.inp) v(inx81) v(iny81) v(xcase81.nbias) v(outn81) v(outp81) v(xcase81.p_bias) v(rctrl81) v(xcase81.s1) v(xcase81.s2) v(vdd81)
ac dec 50 1meg 100g
wrdata ac_336.txt v(outp0) v(outn0) v(vid0) v(outp81) v(outn81) v(vid81)
alter Vr0 1.458
alter Vc0 0.027
op
wrdata op_337.txt i(vsupply0) v(xcase0.att_n0) v(xcase0.att_n1) v(xcase0.att_n2) v(xcase0.att_p0) v(xcase0.att_p1) v(xcase0.att_p2) v(cctrl0) v(cm0) v(xcase0.inn) v(xcase0.inp) v(inx0) v(iny0) v(xcase0.nbias) v(outn0) v(outp0) v(xcase0.p_bias) v(xcase0.rc_ct) v(xcase0.rc_gate) v(xcase0.rc_mid) v(rctrl0) v(xcase0.s1) v(xcase0.s2) v(vdd0) i(vsupply81) v(xcase81.att_n0) v(xcase81.att_n1) v(xcase81.att_n2) v(xcase81.att_p0) v(xcase81.att_p1) v(xcase81.att_p2) v(cctrl81) v(cm81) v(xcase81.inn) v(xcase81.inp) v(inx81) v(iny81) v(xcase81.nbias) v(outn81) v(outp81) v(xcase81.p_bias) v(rctrl81) v(xcase81.s1) v(xcase81.s2) v(vdd81)
ac dec 50 1meg 100g
wrdata ac_337.txt v(outp0) v(outn0) v(vid0) v(outp81) v(outn81) v(vid81)
alter Vr0 1.458
alter Vc0 0.054
op
wrdata op_338.txt i(vsupply0) v(xcase0.att_n0) v(xcase0.att_n1) v(xcase0.att_n2) v(xcase0.att_p0) v(xcase0.att_p1) v(xcase0.att_p2) v(cctrl0) v(cm0) v(xcase0.inn) v(xcase0.inp) v(inx0) v(iny0) v(xcase0.nbias) v(outn0) v(outp0) v(xcase0.p_bias) v(xcase0.rc_ct) v(xcase0.rc_gate) v(xcase0.rc_mid) v(rctrl0) v(xcase0.s1) v(xcase0.s2) v(vdd0) i(vsupply81) v(xcase81.att_n0) v(xcase81.att_n1) v(xcase81.att_n2) v(xcase81.att_p0) v(xcase81.att_p1) v(xcase81.att_p2) v(cctrl81) v(cm81) v(xcase81.inn) v(xcase81.inp) v(inx81) v(iny81) v(xcase81.nbias) v(outn81) v(outp81) v(xcase81.p_bias) v(rctrl81) v(xcase81.s1) v(xcase81.s2) v(vdd81)
ac dec 50 1meg 100g
wrdata ac_338.txt v(outp0) v(outn0) v(vid0) v(outp81) v(outn81) v(vid81)
alter Vr0 1.458
alter Vc0 0.081
op
wrdata op_339.txt i(vsupply0) v(xcase0.att_n0) v(xcase0.att_n1) v(xcase0.att_n2) v(xcase0.att_p0) v(xcase0.att_p1) v(xcase0.att_p2) v(cctrl0) v(cm0) v(xcase0.inn) v(xcase0.inp) v(inx0) v(iny0) v(xcase0.nbias) v(outn0) v(outp0) v(xcase0.p_bias) v(xcase0.rc_ct) v(xcase0.rc_gate) v(xcase0.rc_mid) v(rctrl0) v(xcase0.s1) v(xcase0.s2) v(vdd0) i(vsupply81) v(xcase81.att_n0) v(xcase81.att_n1) v(xcase81.att_n2) v(xcase81.att_p0) v(xcase81.att_p1) v(xcase81.att_p2) v(cctrl81) v(cm81) v(xcase81.inn) v(xcase81.inp) v(inx81) v(iny81) v(xcase81.nbias) v(outn81) v(outp81) v(xcase81.p_bias) v(rctrl81) v(xcase81.s1) v(xcase81.s2) v(vdd81)
ac dec 50 1meg 100g
wrdata ac_339.txt v(outp0) v(outn0) v(vid0) v(outp81) v(outn81) v(vid81)
alter Vr0 1.458
alter Vc0 0.108
op
wrdata op_340.txt i(vsupply0) v(xcase0.att_n0) v(xcase0.att_n1) v(xcase0.att_n2) v(xcase0.att_p0) v(xcase0.att_p1) v(xcase0.att_p2) v(cctrl0) v(cm0) v(xcase0.inn) v(xcase0.inp) v(inx0) v(iny0) v(xcase0.nbias) v(outn0) v(outp0) v(xcase0.p_bias) v(xcase0.rc_ct) v(xcase0.rc_gate) v(xcase0.rc_mid) v(rctrl0) v(xcase0.s1) v(xcase0.s2) v(vdd0) i(vsupply81) v(xcase81.att_n0) v(xcase81.att_n1) v(xcase81.att_n2) v(xcase81.att_p0) v(xcase81.att_p1) v(xcase81.att_p2) v(cctrl81) v(cm81) v(xcase81.inn) v(xcase81.inp) v(inx81) v(iny81) v(xcase81.nbias) v(outn81) v(outp81) v(xcase81.p_bias) v(rctrl81) v(xcase81.s1) v(xcase81.s2) v(vdd81)
ac dec 50 1meg 100g
wrdata ac_340.txt v(outp0) v(outn0) v(vid0) v(outp81) v(outn81) v(vid81)
alter Vr0 1.458
alter Vc0 0.135
op
wrdata op_341.txt i(vsupply0) v(xcase0.att_n0) v(xcase0.att_n1) v(xcase0.att_n2) v(xcase0.att_p0) v(xcase0.att_p1) v(xcase0.att_p2) v(cctrl0) v(cm0) v(xcase0.inn) v(xcase0.inp) v(inx0) v(iny0) v(xcase0.nbias) v(outn0) v(outp0) v(xcase0.p_bias) v(xcase0.rc_ct) v(xcase0.rc_gate) v(xcase0.rc_mid) v(rctrl0) v(xcase0.s1) v(xcase0.s2) v(vdd0) i(vsupply81) v(xcase81.att_n0) v(xcase81.att_n1) v(xcase81.att_n2) v(xcase81.att_p0) v(xcase81.att_p1) v(xcase81.att_p2) v(cctrl81) v(cm81) v(xcase81.inn) v(xcase81.inp) v(inx81) v(iny81) v(xcase81.nbias) v(outn81) v(outp81) v(xcase81.p_bias) v(rctrl81) v(xcase81.s1) v(xcase81.s2) v(vdd81)
ac dec 50 1meg 100g
wrdata ac_341.txt v(outp0) v(outn0) v(vid0) v(outp81) v(outn81) v(vid81)
alter Vr0 1.458
alter Vc0 0.162
op
wrdata op_342.txt i(vsupply0) v(xcase0.att_n0) v(xcase0.att_n1) v(xcase0.att_n2) v(xcase0.att_p0) v(xcase0.att_p1) v(xcase0.att_p2) v(cctrl0) v(cm0) v(xcase0.inn) v(xcase0.inp) v(inx0) v(iny0) v(xcase0.nbias) v(outn0) v(outp0) v(xcase0.p_bias) v(xcase0.rc_ct) v(xcase0.rc_gate) v(xcase0.rc_mid) v(rctrl0) v(xcase0.s1) v(xcase0.s2) v(vdd0) i(vsupply81) v(xcase81.att_n0) v(xcase81.att_n1) v(xcase81.att_n2) v(xcase81.att_p0) v(xcase81.att_p1) v(xcase81.att_p2) v(cctrl81) v(cm81) v(xcase81.inn) v(xcase81.inp) v(inx81) v(iny81) v(xcase81.nbias) v(outn81) v(outp81) v(xcase81.p_bias) v(rctrl81) v(xcase81.s1) v(xcase81.s2) v(vdd81)
ac dec 50 1meg 100g
wrdata ac_342.txt v(outp0) v(outn0) v(vid0) v(outp81) v(outn81) v(vid81)
alter Vr0 1.458
alter Vc0 0.189
op
wrdata op_343.txt i(vsupply0) v(xcase0.att_n0) v(xcase0.att_n1) v(xcase0.att_n2) v(xcase0.att_p0) v(xcase0.att_p1) v(xcase0.att_p2) v(cctrl0) v(cm0) v(xcase0.inn) v(xcase0.inp) v(inx0) v(iny0) v(xcase0.nbias) v(outn0) v(outp0) v(xcase0.p_bias) v(xcase0.rc_ct) v(xcase0.rc_gate) v(xcase0.rc_mid) v(rctrl0) v(xcase0.s1) v(xcase0.s2) v(vdd0) i(vsupply81) v(xcase81.att_n0) v(xcase81.att_n1) v(xcase81.att_n2) v(xcase81.att_p0) v(xcase81.att_p1) v(xcase81.att_p2) v(cctrl81) v(cm81) v(xcase81.inn) v(xcase81.inp) v(inx81) v(iny81) v(xcase81.nbias) v(outn81) v(outp81) v(xcase81.p_bias) v(rctrl81) v(xcase81.s1) v(xcase81.s2) v(vdd81)
ac dec 50 1meg 100g
wrdata ac_343.txt v(outp0) v(outn0) v(vid0) v(outp81) v(outn81) v(vid81)
alter Vr0 1.458
alter Vc0 0.216
op
wrdata op_344.txt i(vsupply0) v(xcase0.att_n0) v(xcase0.att_n1) v(xcase0.att_n2) v(xcase0.att_p0) v(xcase0.att_p1) v(xcase0.att_p2) v(cctrl0) v(cm0) v(xcase0.inn) v(xcase0.inp) v(inx0) v(iny0) v(xcase0.nbias) v(outn0) v(outp0) v(xcase0.p_bias) v(xcase0.rc_ct) v(xcase0.rc_gate) v(xcase0.rc_mid) v(rctrl0) v(xcase0.s1) v(xcase0.s2) v(vdd0) i(vsupply81) v(xcase81.att_n0) v(xcase81.att_n1) v(xcase81.att_n2) v(xcase81.att_p0) v(xcase81.att_p1) v(xcase81.att_p2) v(cctrl81) v(cm81) v(xcase81.inn) v(xcase81.inp) v(inx81) v(iny81) v(xcase81.nbias) v(outn81) v(outp81) v(xcase81.p_bias) v(rctrl81) v(xcase81.s1) v(xcase81.s2) v(vdd81)
ac dec 50 1meg 100g
wrdata ac_344.txt v(outp0) v(outn0) v(vid0) v(outp81) v(outn81) v(vid81)
alter Vr0 1.458
alter Vc0 0.243
op
wrdata op_345.txt i(vsupply0) v(xcase0.att_n0) v(xcase0.att_n1) v(xcase0.att_n2) v(xcase0.att_p0) v(xcase0.att_p1) v(xcase0.att_p2) v(cctrl0) v(cm0) v(xcase0.inn) v(xcase0.inp) v(inx0) v(iny0) v(xcase0.nbias) v(outn0) v(outp0) v(xcase0.p_bias) v(xcase0.rc_ct) v(xcase0.rc_gate) v(xcase0.rc_mid) v(rctrl0) v(xcase0.s1) v(xcase0.s2) v(vdd0) i(vsupply81) v(xcase81.att_n0) v(xcase81.att_n1) v(xcase81.att_n2) v(xcase81.att_p0) v(xcase81.att_p1) v(xcase81.att_p2) v(cctrl81) v(cm81) v(xcase81.inn) v(xcase81.inp) v(inx81) v(iny81) v(xcase81.nbias) v(outn81) v(outp81) v(xcase81.p_bias) v(rctrl81) v(xcase81.s1) v(xcase81.s2) v(vdd81)
ac dec 50 1meg 100g
wrdata ac_345.txt v(outp0) v(outn0) v(vid0) v(outp81) v(outn81) v(vid81)
alter Vr0 1.458
alter Vc0 0.27
op
wrdata op_346.txt i(vsupply0) v(xcase0.att_n0) v(xcase0.att_n1) v(xcase0.att_n2) v(xcase0.att_p0) v(xcase0.att_p1) v(xcase0.att_p2) v(cctrl0) v(cm0) v(xcase0.inn) v(xcase0.inp) v(inx0) v(iny0) v(xcase0.nbias) v(outn0) v(outp0) v(xcase0.p_bias) v(xcase0.rc_ct) v(xcase0.rc_gate) v(xcase0.rc_mid) v(rctrl0) v(xcase0.s1) v(xcase0.s2) v(vdd0) i(vsupply81) v(xcase81.att_n0) v(xcase81.att_n1) v(xcase81.att_n2) v(xcase81.att_p0) v(xcase81.att_p1) v(xcase81.att_p2) v(cctrl81) v(cm81) v(xcase81.inn) v(xcase81.inp) v(inx81) v(iny81) v(xcase81.nbias) v(outn81) v(outp81) v(xcase81.p_bias) v(rctrl81) v(xcase81.s1) v(xcase81.s2) v(vdd81)
ac dec 50 1meg 100g
wrdata ac_346.txt v(outp0) v(outn0) v(vid0) v(outp81) v(outn81) v(vid81)
alter Vr0 1.458
alter Vc0 0.297
op
wrdata op_347.txt i(vsupply0) v(xcase0.att_n0) v(xcase0.att_n1) v(xcase0.att_n2) v(xcase0.att_p0) v(xcase0.att_p1) v(xcase0.att_p2) v(cctrl0) v(cm0) v(xcase0.inn) v(xcase0.inp) v(inx0) v(iny0) v(xcase0.nbias) v(outn0) v(outp0) v(xcase0.p_bias) v(xcase0.rc_ct) v(xcase0.rc_gate) v(xcase0.rc_mid) v(rctrl0) v(xcase0.s1) v(xcase0.s2) v(vdd0) i(vsupply81) v(xcase81.att_n0) v(xcase81.att_n1) v(xcase81.att_n2) v(xcase81.att_p0) v(xcase81.att_p1) v(xcase81.att_p2) v(cctrl81) v(cm81) v(xcase81.inn) v(xcase81.inp) v(inx81) v(iny81) v(xcase81.nbias) v(outn81) v(outp81) v(xcase81.p_bias) v(rctrl81) v(xcase81.s1) v(xcase81.s2) v(vdd81)
ac dec 50 1meg 100g
wrdata ac_347.txt v(outp0) v(outn0) v(vid0) v(outp81) v(outn81) v(vid81)
alter Vr0 1.458
alter Vc0 0.324
op
wrdata op_348.txt i(vsupply0) v(xcase0.att_n0) v(xcase0.att_n1) v(xcase0.att_n2) v(xcase0.att_p0) v(xcase0.att_p1) v(xcase0.att_p2) v(cctrl0) v(cm0) v(xcase0.inn) v(xcase0.inp) v(inx0) v(iny0) v(xcase0.nbias) v(outn0) v(outp0) v(xcase0.p_bias) v(xcase0.rc_ct) v(xcase0.rc_gate) v(xcase0.rc_mid) v(rctrl0) v(xcase0.s1) v(xcase0.s2) v(vdd0) i(vsupply81) v(xcase81.att_n0) v(xcase81.att_n1) v(xcase81.att_n2) v(xcase81.att_p0) v(xcase81.att_p1) v(xcase81.att_p2) v(cctrl81) v(cm81) v(xcase81.inn) v(xcase81.inp) v(inx81) v(iny81) v(xcase81.nbias) v(outn81) v(outp81) v(xcase81.p_bias) v(rctrl81) v(xcase81.s1) v(xcase81.s2) v(vdd81)
ac dec 50 1meg 100g
wrdata ac_348.txt v(outp0) v(outn0) v(vid0) v(outp81) v(outn81) v(vid81)
alter Vr0 1.458
alter Vc0 0.351
op
wrdata op_349.txt i(vsupply0) v(xcase0.att_n0) v(xcase0.att_n1) v(xcase0.att_n2) v(xcase0.att_p0) v(xcase0.att_p1) v(xcase0.att_p2) v(cctrl0) v(cm0) v(xcase0.inn) v(xcase0.inp) v(inx0) v(iny0) v(xcase0.nbias) v(outn0) v(outp0) v(xcase0.p_bias) v(xcase0.rc_ct) v(xcase0.rc_gate) v(xcase0.rc_mid) v(rctrl0) v(xcase0.s1) v(xcase0.s2) v(vdd0) i(vsupply81) v(xcase81.att_n0) v(xcase81.att_n1) v(xcase81.att_n2) v(xcase81.att_p0) v(xcase81.att_p1) v(xcase81.att_p2) v(cctrl81) v(cm81) v(xcase81.inn) v(xcase81.inp) v(inx81) v(iny81) v(xcase81.nbias) v(outn81) v(outp81) v(xcase81.p_bias) v(rctrl81) v(xcase81.s1) v(xcase81.s2) v(vdd81)
ac dec 50 1meg 100g
wrdata ac_349.txt v(outp0) v(outn0) v(vid0) v(outp81) v(outn81) v(vid81)
alter Vr0 1.458
alter Vc0 0.378
op
wrdata op_350.txt i(vsupply0) v(xcase0.att_n0) v(xcase0.att_n1) v(xcase0.att_n2) v(xcase0.att_p0) v(xcase0.att_p1) v(xcase0.att_p2) v(cctrl0) v(cm0) v(xcase0.inn) v(xcase0.inp) v(inx0) v(iny0) v(xcase0.nbias) v(outn0) v(outp0) v(xcase0.p_bias) v(xcase0.rc_ct) v(xcase0.rc_gate) v(xcase0.rc_mid) v(rctrl0) v(xcase0.s1) v(xcase0.s2) v(vdd0) i(vsupply81) v(xcase81.att_n0) v(xcase81.att_n1) v(xcase81.att_n2) v(xcase81.att_p0) v(xcase81.att_p1) v(xcase81.att_p2) v(cctrl81) v(cm81) v(xcase81.inn) v(xcase81.inp) v(inx81) v(iny81) v(xcase81.nbias) v(outn81) v(outp81) v(xcase81.p_bias) v(rctrl81) v(xcase81.s1) v(xcase81.s2) v(vdd81)
ac dec 50 1meg 100g
wrdata ac_350.txt v(outp0) v(outn0) v(vid0) v(outp81) v(outn81) v(vid81)
alter Vr0 1.458
alter Vc0 0.405
op
wrdata op_351.txt i(vsupply0) v(xcase0.att_n0) v(xcase0.att_n1) v(xcase0.att_n2) v(xcase0.att_p0) v(xcase0.att_p1) v(xcase0.att_p2) v(cctrl0) v(cm0) v(xcase0.inn) v(xcase0.inp) v(inx0) v(iny0) v(xcase0.nbias) v(outn0) v(outp0) v(xcase0.p_bias) v(xcase0.rc_ct) v(xcase0.rc_gate) v(xcase0.rc_mid) v(rctrl0) v(xcase0.s1) v(xcase0.s2) v(vdd0) i(vsupply81) v(xcase81.att_n0) v(xcase81.att_n1) v(xcase81.att_n2) v(xcase81.att_p0) v(xcase81.att_p1) v(xcase81.att_p2) v(cctrl81) v(cm81) v(xcase81.inn) v(xcase81.inp) v(inx81) v(iny81) v(xcase81.nbias) v(outn81) v(outp81) v(xcase81.p_bias) v(rctrl81) v(xcase81.s1) v(xcase81.s2) v(vdd81)
ac dec 50 1meg 100g
wrdata ac_351.txt v(outp0) v(outn0) v(vid0) v(outp81) v(outn81) v(vid81)
alter Vr0 1.458
alter Vc0 0.432
op
wrdata op_352.txt i(vsupply0) v(xcase0.att_n0) v(xcase0.att_n1) v(xcase0.att_n2) v(xcase0.att_p0) v(xcase0.att_p1) v(xcase0.att_p2) v(cctrl0) v(cm0) v(xcase0.inn) v(xcase0.inp) v(inx0) v(iny0) v(xcase0.nbias) v(outn0) v(outp0) v(xcase0.p_bias) v(xcase0.rc_ct) v(xcase0.rc_gate) v(xcase0.rc_mid) v(rctrl0) v(xcase0.s1) v(xcase0.s2) v(vdd0) i(vsupply81) v(xcase81.att_n0) v(xcase81.att_n1) v(xcase81.att_n2) v(xcase81.att_p0) v(xcase81.att_p1) v(xcase81.att_p2) v(cctrl81) v(cm81) v(xcase81.inn) v(xcase81.inp) v(inx81) v(iny81) v(xcase81.nbias) v(outn81) v(outp81) v(xcase81.p_bias) v(rctrl81) v(xcase81.s1) v(xcase81.s2) v(vdd81)
ac dec 50 1meg 100g
wrdata ac_352.txt v(outp0) v(outn0) v(vid0) v(outp81) v(outn81) v(vid81)
alter Vr0 1.458
alter Vc0 0.459
op
wrdata op_353.txt i(vsupply0) v(xcase0.att_n0) v(xcase0.att_n1) v(xcase0.att_n2) v(xcase0.att_p0) v(xcase0.att_p1) v(xcase0.att_p2) v(cctrl0) v(cm0) v(xcase0.inn) v(xcase0.inp) v(inx0) v(iny0) v(xcase0.nbias) v(outn0) v(outp0) v(xcase0.p_bias) v(xcase0.rc_ct) v(xcase0.rc_gate) v(xcase0.rc_mid) v(rctrl0) v(xcase0.s1) v(xcase0.s2) v(vdd0) i(vsupply81) v(xcase81.att_n0) v(xcase81.att_n1) v(xcase81.att_n2) v(xcase81.att_p0) v(xcase81.att_p1) v(xcase81.att_p2) v(cctrl81) v(cm81) v(xcase81.inn) v(xcase81.inp) v(inx81) v(iny81) v(xcase81.nbias) v(outn81) v(outp81) v(xcase81.p_bias) v(rctrl81) v(xcase81.s1) v(xcase81.s2) v(vdd81)
ac dec 50 1meg 100g
wrdata ac_353.txt v(outp0) v(outn0) v(vid0) v(outp81) v(outn81) v(vid81)
alter Vr0 1.458
alter Vc0 0.486
op
wrdata op_354.txt i(vsupply0) v(xcase0.att_n0) v(xcase0.att_n1) v(xcase0.att_n2) v(xcase0.att_p0) v(xcase0.att_p1) v(xcase0.att_p2) v(cctrl0) v(cm0) v(xcase0.inn) v(xcase0.inp) v(inx0) v(iny0) v(xcase0.nbias) v(outn0) v(outp0) v(xcase0.p_bias) v(xcase0.rc_ct) v(xcase0.rc_gate) v(xcase0.rc_mid) v(rctrl0) v(xcase0.s1) v(xcase0.s2) v(vdd0) i(vsupply81) v(xcase81.att_n0) v(xcase81.att_n1) v(xcase81.att_n2) v(xcase81.att_p0) v(xcase81.att_p1) v(xcase81.att_p2) v(cctrl81) v(cm81) v(xcase81.inn) v(xcase81.inp) v(inx81) v(iny81) v(xcase81.nbias) v(outn81) v(outp81) v(xcase81.p_bias) v(rctrl81) v(xcase81.s1) v(xcase81.s2) v(vdd81)
ac dec 50 1meg 100g
wrdata ac_354.txt v(outp0) v(outn0) v(vid0) v(outp81) v(outn81) v(vid81)
alter Vr0 1.458
alter Vc0 0.513
op
wrdata op_355.txt i(vsupply0) v(xcase0.att_n0) v(xcase0.att_n1) v(xcase0.att_n2) v(xcase0.att_p0) v(xcase0.att_p1) v(xcase0.att_p2) v(cctrl0) v(cm0) v(xcase0.inn) v(xcase0.inp) v(inx0) v(iny0) v(xcase0.nbias) v(outn0) v(outp0) v(xcase0.p_bias) v(xcase0.rc_ct) v(xcase0.rc_gate) v(xcase0.rc_mid) v(rctrl0) v(xcase0.s1) v(xcase0.s2) v(vdd0) i(vsupply81) v(xcase81.att_n0) v(xcase81.att_n1) v(xcase81.att_n2) v(xcase81.att_p0) v(xcase81.att_p1) v(xcase81.att_p2) v(cctrl81) v(cm81) v(xcase81.inn) v(xcase81.inp) v(inx81) v(iny81) v(xcase81.nbias) v(outn81) v(outp81) v(xcase81.p_bias) v(rctrl81) v(xcase81.s1) v(xcase81.s2) v(vdd81)
ac dec 50 1meg 100g
wrdata ac_355.txt v(outp0) v(outn0) v(vid0) v(outp81) v(outn81) v(vid81)
alter Vr0 1.458
alter Vc0 0.54
op
wrdata op_356.txt i(vsupply0) v(xcase0.att_n0) v(xcase0.att_n1) v(xcase0.att_n2) v(xcase0.att_p0) v(xcase0.att_p1) v(xcase0.att_p2) v(cctrl0) v(cm0) v(xcase0.inn) v(xcase0.inp) v(inx0) v(iny0) v(xcase0.nbias) v(outn0) v(outp0) v(xcase0.p_bias) v(xcase0.rc_ct) v(xcase0.rc_gate) v(xcase0.rc_mid) v(rctrl0) v(xcase0.s1) v(xcase0.s2) v(vdd0) i(vsupply81) v(xcase81.att_n0) v(xcase81.att_n1) v(xcase81.att_n2) v(xcase81.att_p0) v(xcase81.att_p1) v(xcase81.att_p2) v(cctrl81) v(cm81) v(xcase81.inn) v(xcase81.inp) v(inx81) v(iny81) v(xcase81.nbias) v(outn81) v(outp81) v(xcase81.p_bias) v(rctrl81) v(xcase81.s1) v(xcase81.s2) v(vdd81)
ac dec 50 1meg 100g
wrdata ac_356.txt v(outp0) v(outn0) v(vid0) v(outp81) v(outn81) v(vid81)
alter Vr0 1.476
alter Vc0 0
op
wrdata op_357.txt i(vsupply0) v(xcase0.att_n0) v(xcase0.att_n1) v(xcase0.att_n2) v(xcase0.att_p0) v(xcase0.att_p1) v(xcase0.att_p2) v(cctrl0) v(cm0) v(xcase0.inn) v(xcase0.inp) v(inx0) v(iny0) v(xcase0.nbias) v(outn0) v(outp0) v(xcase0.p_bias) v(xcase0.rc_ct) v(xcase0.rc_gate) v(xcase0.rc_mid) v(rctrl0) v(xcase0.s1) v(xcase0.s2) v(vdd0) i(vsupply81) v(xcase81.att_n0) v(xcase81.att_n1) v(xcase81.att_n2) v(xcase81.att_p0) v(xcase81.att_p1) v(xcase81.att_p2) v(cctrl81) v(cm81) v(xcase81.inn) v(xcase81.inp) v(inx81) v(iny81) v(xcase81.nbias) v(outn81) v(outp81) v(xcase81.p_bias) v(rctrl81) v(xcase81.s1) v(xcase81.s2) v(vdd81)
ac dec 50 1meg 100g
wrdata ac_357.txt v(outp0) v(outn0) v(vid0) v(outp81) v(outn81) v(vid81)
alter Vr0 1.476
alter Vc0 0.027
op
wrdata op_358.txt i(vsupply0) v(xcase0.att_n0) v(xcase0.att_n1) v(xcase0.att_n2) v(xcase0.att_p0) v(xcase0.att_p1) v(xcase0.att_p2) v(cctrl0) v(cm0) v(xcase0.inn) v(xcase0.inp) v(inx0) v(iny0) v(xcase0.nbias) v(outn0) v(outp0) v(xcase0.p_bias) v(xcase0.rc_ct) v(xcase0.rc_gate) v(xcase0.rc_mid) v(rctrl0) v(xcase0.s1) v(xcase0.s2) v(vdd0) i(vsupply81) v(xcase81.att_n0) v(xcase81.att_n1) v(xcase81.att_n2) v(xcase81.att_p0) v(xcase81.att_p1) v(xcase81.att_p2) v(cctrl81) v(cm81) v(xcase81.inn) v(xcase81.inp) v(inx81) v(iny81) v(xcase81.nbias) v(outn81) v(outp81) v(xcase81.p_bias) v(rctrl81) v(xcase81.s1) v(xcase81.s2) v(vdd81)
ac dec 50 1meg 100g
wrdata ac_358.txt v(outp0) v(outn0) v(vid0) v(outp81) v(outn81) v(vid81)
alter Vr0 1.476
alter Vc0 0.054
op
wrdata op_359.txt i(vsupply0) v(xcase0.att_n0) v(xcase0.att_n1) v(xcase0.att_n2) v(xcase0.att_p0) v(xcase0.att_p1) v(xcase0.att_p2) v(cctrl0) v(cm0) v(xcase0.inn) v(xcase0.inp) v(inx0) v(iny0) v(xcase0.nbias) v(outn0) v(outp0) v(xcase0.p_bias) v(xcase0.rc_ct) v(xcase0.rc_gate) v(xcase0.rc_mid) v(rctrl0) v(xcase0.s1) v(xcase0.s2) v(vdd0) i(vsupply81) v(xcase81.att_n0) v(xcase81.att_n1) v(xcase81.att_n2) v(xcase81.att_p0) v(xcase81.att_p1) v(xcase81.att_p2) v(cctrl81) v(cm81) v(xcase81.inn) v(xcase81.inp) v(inx81) v(iny81) v(xcase81.nbias) v(outn81) v(outp81) v(xcase81.p_bias) v(rctrl81) v(xcase81.s1) v(xcase81.s2) v(vdd81)
ac dec 50 1meg 100g
wrdata ac_359.txt v(outp0) v(outn0) v(vid0) v(outp81) v(outn81) v(vid81)
alter Vr0 1.476
alter Vc0 0.081
op
wrdata op_360.txt i(vsupply0) v(xcase0.att_n0) v(xcase0.att_n1) v(xcase0.att_n2) v(xcase0.att_p0) v(xcase0.att_p1) v(xcase0.att_p2) v(cctrl0) v(cm0) v(xcase0.inn) v(xcase0.inp) v(inx0) v(iny0) v(xcase0.nbias) v(outn0) v(outp0) v(xcase0.p_bias) v(xcase0.rc_ct) v(xcase0.rc_gate) v(xcase0.rc_mid) v(rctrl0) v(xcase0.s1) v(xcase0.s2) v(vdd0) i(vsupply81) v(xcase81.att_n0) v(xcase81.att_n1) v(xcase81.att_n2) v(xcase81.att_p0) v(xcase81.att_p1) v(xcase81.att_p2) v(cctrl81) v(cm81) v(xcase81.inn) v(xcase81.inp) v(inx81) v(iny81) v(xcase81.nbias) v(outn81) v(outp81) v(xcase81.p_bias) v(rctrl81) v(xcase81.s1) v(xcase81.s2) v(vdd81)
ac dec 50 1meg 100g
wrdata ac_360.txt v(outp0) v(outn0) v(vid0) v(outp81) v(outn81) v(vid81)
alter Vr0 1.476
alter Vc0 0.108
op
wrdata op_361.txt i(vsupply0) v(xcase0.att_n0) v(xcase0.att_n1) v(xcase0.att_n2) v(xcase0.att_p0) v(xcase0.att_p1) v(xcase0.att_p2) v(cctrl0) v(cm0) v(xcase0.inn) v(xcase0.inp) v(inx0) v(iny0) v(xcase0.nbias) v(outn0) v(outp0) v(xcase0.p_bias) v(xcase0.rc_ct) v(xcase0.rc_gate) v(xcase0.rc_mid) v(rctrl0) v(xcase0.s1) v(xcase0.s2) v(vdd0) i(vsupply81) v(xcase81.att_n0) v(xcase81.att_n1) v(xcase81.att_n2) v(xcase81.att_p0) v(xcase81.att_p1) v(xcase81.att_p2) v(cctrl81) v(cm81) v(xcase81.inn) v(xcase81.inp) v(inx81) v(iny81) v(xcase81.nbias) v(outn81) v(outp81) v(xcase81.p_bias) v(rctrl81) v(xcase81.s1) v(xcase81.s2) v(vdd81)
ac dec 50 1meg 100g
wrdata ac_361.txt v(outp0) v(outn0) v(vid0) v(outp81) v(outn81) v(vid81)
alter Vr0 1.476
alter Vc0 0.135
op
wrdata op_362.txt i(vsupply0) v(xcase0.att_n0) v(xcase0.att_n1) v(xcase0.att_n2) v(xcase0.att_p0) v(xcase0.att_p1) v(xcase0.att_p2) v(cctrl0) v(cm0) v(xcase0.inn) v(xcase0.inp) v(inx0) v(iny0) v(xcase0.nbias) v(outn0) v(outp0) v(xcase0.p_bias) v(xcase0.rc_ct) v(xcase0.rc_gate) v(xcase0.rc_mid) v(rctrl0) v(xcase0.s1) v(xcase0.s2) v(vdd0) i(vsupply81) v(xcase81.att_n0) v(xcase81.att_n1) v(xcase81.att_n2) v(xcase81.att_p0) v(xcase81.att_p1) v(xcase81.att_p2) v(cctrl81) v(cm81) v(xcase81.inn) v(xcase81.inp) v(inx81) v(iny81) v(xcase81.nbias) v(outn81) v(outp81) v(xcase81.p_bias) v(rctrl81) v(xcase81.s1) v(xcase81.s2) v(vdd81)
ac dec 50 1meg 100g
wrdata ac_362.txt v(outp0) v(outn0) v(vid0) v(outp81) v(outn81) v(vid81)
alter Vr0 1.476
alter Vc0 0.162
op
wrdata op_363.txt i(vsupply0) v(xcase0.att_n0) v(xcase0.att_n1) v(xcase0.att_n2) v(xcase0.att_p0) v(xcase0.att_p1) v(xcase0.att_p2) v(cctrl0) v(cm0) v(xcase0.inn) v(xcase0.inp) v(inx0) v(iny0) v(xcase0.nbias) v(outn0) v(outp0) v(xcase0.p_bias) v(xcase0.rc_ct) v(xcase0.rc_gate) v(xcase0.rc_mid) v(rctrl0) v(xcase0.s1) v(xcase0.s2) v(vdd0) i(vsupply81) v(xcase81.att_n0) v(xcase81.att_n1) v(xcase81.att_n2) v(xcase81.att_p0) v(xcase81.att_p1) v(xcase81.att_p2) v(cctrl81) v(cm81) v(xcase81.inn) v(xcase81.inp) v(inx81) v(iny81) v(xcase81.nbias) v(outn81) v(outp81) v(xcase81.p_bias) v(rctrl81) v(xcase81.s1) v(xcase81.s2) v(vdd81)
ac dec 50 1meg 100g
wrdata ac_363.txt v(outp0) v(outn0) v(vid0) v(outp81) v(outn81) v(vid81)
alter Vr0 1.476
alter Vc0 0.189
op
wrdata op_364.txt i(vsupply0) v(xcase0.att_n0) v(xcase0.att_n1) v(xcase0.att_n2) v(xcase0.att_p0) v(xcase0.att_p1) v(xcase0.att_p2) v(cctrl0) v(cm0) v(xcase0.inn) v(xcase0.inp) v(inx0) v(iny0) v(xcase0.nbias) v(outn0) v(outp0) v(xcase0.p_bias) v(xcase0.rc_ct) v(xcase0.rc_gate) v(xcase0.rc_mid) v(rctrl0) v(xcase0.s1) v(xcase0.s2) v(vdd0) i(vsupply81) v(xcase81.att_n0) v(xcase81.att_n1) v(xcase81.att_n2) v(xcase81.att_p0) v(xcase81.att_p1) v(xcase81.att_p2) v(cctrl81) v(cm81) v(xcase81.inn) v(xcase81.inp) v(inx81) v(iny81) v(xcase81.nbias) v(outn81) v(outp81) v(xcase81.p_bias) v(rctrl81) v(xcase81.s1) v(xcase81.s2) v(vdd81)
ac dec 50 1meg 100g
wrdata ac_364.txt v(outp0) v(outn0) v(vid0) v(outp81) v(outn81) v(vid81)
alter Vr0 1.476
alter Vc0 0.216
op
wrdata op_365.txt i(vsupply0) v(xcase0.att_n0) v(xcase0.att_n1) v(xcase0.att_n2) v(xcase0.att_p0) v(xcase0.att_p1) v(xcase0.att_p2) v(cctrl0) v(cm0) v(xcase0.inn) v(xcase0.inp) v(inx0) v(iny0) v(xcase0.nbias) v(outn0) v(outp0) v(xcase0.p_bias) v(xcase0.rc_ct) v(xcase0.rc_gate) v(xcase0.rc_mid) v(rctrl0) v(xcase0.s1) v(xcase0.s2) v(vdd0) i(vsupply81) v(xcase81.att_n0) v(xcase81.att_n1) v(xcase81.att_n2) v(xcase81.att_p0) v(xcase81.att_p1) v(xcase81.att_p2) v(cctrl81) v(cm81) v(xcase81.inn) v(xcase81.inp) v(inx81) v(iny81) v(xcase81.nbias) v(outn81) v(outp81) v(xcase81.p_bias) v(rctrl81) v(xcase81.s1) v(xcase81.s2) v(vdd81)
ac dec 50 1meg 100g
wrdata ac_365.txt v(outp0) v(outn0) v(vid0) v(outp81) v(outn81) v(vid81)
alter Vr0 1.476
alter Vc0 0.243
op
wrdata op_366.txt i(vsupply0) v(xcase0.att_n0) v(xcase0.att_n1) v(xcase0.att_n2) v(xcase0.att_p0) v(xcase0.att_p1) v(xcase0.att_p2) v(cctrl0) v(cm0) v(xcase0.inn) v(xcase0.inp) v(inx0) v(iny0) v(xcase0.nbias) v(outn0) v(outp0) v(xcase0.p_bias) v(xcase0.rc_ct) v(xcase0.rc_gate) v(xcase0.rc_mid) v(rctrl0) v(xcase0.s1) v(xcase0.s2) v(vdd0) i(vsupply81) v(xcase81.att_n0) v(xcase81.att_n1) v(xcase81.att_n2) v(xcase81.att_p0) v(xcase81.att_p1) v(xcase81.att_p2) v(cctrl81) v(cm81) v(xcase81.inn) v(xcase81.inp) v(inx81) v(iny81) v(xcase81.nbias) v(outn81) v(outp81) v(xcase81.p_bias) v(rctrl81) v(xcase81.s1) v(xcase81.s2) v(vdd81)
ac dec 50 1meg 100g
wrdata ac_366.txt v(outp0) v(outn0) v(vid0) v(outp81) v(outn81) v(vid81)
alter Vr0 1.476
alter Vc0 0.27
op
wrdata op_367.txt i(vsupply0) v(xcase0.att_n0) v(xcase0.att_n1) v(xcase0.att_n2) v(xcase0.att_p0) v(xcase0.att_p1) v(xcase0.att_p2) v(cctrl0) v(cm0) v(xcase0.inn) v(xcase0.inp) v(inx0) v(iny0) v(xcase0.nbias) v(outn0) v(outp0) v(xcase0.p_bias) v(xcase0.rc_ct) v(xcase0.rc_gate) v(xcase0.rc_mid) v(rctrl0) v(xcase0.s1) v(xcase0.s2) v(vdd0) i(vsupply81) v(xcase81.att_n0) v(xcase81.att_n1) v(xcase81.att_n2) v(xcase81.att_p0) v(xcase81.att_p1) v(xcase81.att_p2) v(cctrl81) v(cm81) v(xcase81.inn) v(xcase81.inp) v(inx81) v(iny81) v(xcase81.nbias) v(outn81) v(outp81) v(xcase81.p_bias) v(rctrl81) v(xcase81.s1) v(xcase81.s2) v(vdd81)
ac dec 50 1meg 100g
wrdata ac_367.txt v(outp0) v(outn0) v(vid0) v(outp81) v(outn81) v(vid81)
alter Vr0 1.476
alter Vc0 0.297
op
wrdata op_368.txt i(vsupply0) v(xcase0.att_n0) v(xcase0.att_n1) v(xcase0.att_n2) v(xcase0.att_p0) v(xcase0.att_p1) v(xcase0.att_p2) v(cctrl0) v(cm0) v(xcase0.inn) v(xcase0.inp) v(inx0) v(iny0) v(xcase0.nbias) v(outn0) v(outp0) v(xcase0.p_bias) v(xcase0.rc_ct) v(xcase0.rc_gate) v(xcase0.rc_mid) v(rctrl0) v(xcase0.s1) v(xcase0.s2) v(vdd0) i(vsupply81) v(xcase81.att_n0) v(xcase81.att_n1) v(xcase81.att_n2) v(xcase81.att_p0) v(xcase81.att_p1) v(xcase81.att_p2) v(cctrl81) v(cm81) v(xcase81.inn) v(xcase81.inp) v(inx81) v(iny81) v(xcase81.nbias) v(outn81) v(outp81) v(xcase81.p_bias) v(rctrl81) v(xcase81.s1) v(xcase81.s2) v(vdd81)
ac dec 50 1meg 100g
wrdata ac_368.txt v(outp0) v(outn0) v(vid0) v(outp81) v(outn81) v(vid81)
alter Vr0 1.476
alter Vc0 0.324
op
wrdata op_369.txt i(vsupply0) v(xcase0.att_n0) v(xcase0.att_n1) v(xcase0.att_n2) v(xcase0.att_p0) v(xcase0.att_p1) v(xcase0.att_p2) v(cctrl0) v(cm0) v(xcase0.inn) v(xcase0.inp) v(inx0) v(iny0) v(xcase0.nbias) v(outn0) v(outp0) v(xcase0.p_bias) v(xcase0.rc_ct) v(xcase0.rc_gate) v(xcase0.rc_mid) v(rctrl0) v(xcase0.s1) v(xcase0.s2) v(vdd0) i(vsupply81) v(xcase81.att_n0) v(xcase81.att_n1) v(xcase81.att_n2) v(xcase81.att_p0) v(xcase81.att_p1) v(xcase81.att_p2) v(cctrl81) v(cm81) v(xcase81.inn) v(xcase81.inp) v(inx81) v(iny81) v(xcase81.nbias) v(outn81) v(outp81) v(xcase81.p_bias) v(rctrl81) v(xcase81.s1) v(xcase81.s2) v(vdd81)
ac dec 50 1meg 100g
wrdata ac_369.txt v(outp0) v(outn0) v(vid0) v(outp81) v(outn81) v(vid81)
alter Vr0 1.476
alter Vc0 0.351
op
wrdata op_370.txt i(vsupply0) v(xcase0.att_n0) v(xcase0.att_n1) v(xcase0.att_n2) v(xcase0.att_p0) v(xcase0.att_p1) v(xcase0.att_p2) v(cctrl0) v(cm0) v(xcase0.inn) v(xcase0.inp) v(inx0) v(iny0) v(xcase0.nbias) v(outn0) v(outp0) v(xcase0.p_bias) v(xcase0.rc_ct) v(xcase0.rc_gate) v(xcase0.rc_mid) v(rctrl0) v(xcase0.s1) v(xcase0.s2) v(vdd0) i(vsupply81) v(xcase81.att_n0) v(xcase81.att_n1) v(xcase81.att_n2) v(xcase81.att_p0) v(xcase81.att_p1) v(xcase81.att_p2) v(cctrl81) v(cm81) v(xcase81.inn) v(xcase81.inp) v(inx81) v(iny81) v(xcase81.nbias) v(outn81) v(outp81) v(xcase81.p_bias) v(rctrl81) v(xcase81.s1) v(xcase81.s2) v(vdd81)
ac dec 50 1meg 100g
wrdata ac_370.txt v(outp0) v(outn0) v(vid0) v(outp81) v(outn81) v(vid81)
alter Vr0 1.476
alter Vc0 0.378
op
wrdata op_371.txt i(vsupply0) v(xcase0.att_n0) v(xcase0.att_n1) v(xcase0.att_n2) v(xcase0.att_p0) v(xcase0.att_p1) v(xcase0.att_p2) v(cctrl0) v(cm0) v(xcase0.inn) v(xcase0.inp) v(inx0) v(iny0) v(xcase0.nbias) v(outn0) v(outp0) v(xcase0.p_bias) v(xcase0.rc_ct) v(xcase0.rc_gate) v(xcase0.rc_mid) v(rctrl0) v(xcase0.s1) v(xcase0.s2) v(vdd0) i(vsupply81) v(xcase81.att_n0) v(xcase81.att_n1) v(xcase81.att_n2) v(xcase81.att_p0) v(xcase81.att_p1) v(xcase81.att_p2) v(cctrl81) v(cm81) v(xcase81.inn) v(xcase81.inp) v(inx81) v(iny81) v(xcase81.nbias) v(outn81) v(outp81) v(xcase81.p_bias) v(rctrl81) v(xcase81.s1) v(xcase81.s2) v(vdd81)
ac dec 50 1meg 100g
wrdata ac_371.txt v(outp0) v(outn0) v(vid0) v(outp81) v(outn81) v(vid81)
alter Vr0 1.476
alter Vc0 0.405
op
wrdata op_372.txt i(vsupply0) v(xcase0.att_n0) v(xcase0.att_n1) v(xcase0.att_n2) v(xcase0.att_p0) v(xcase0.att_p1) v(xcase0.att_p2) v(cctrl0) v(cm0) v(xcase0.inn) v(xcase0.inp) v(inx0) v(iny0) v(xcase0.nbias) v(outn0) v(outp0) v(xcase0.p_bias) v(xcase0.rc_ct) v(xcase0.rc_gate) v(xcase0.rc_mid) v(rctrl0) v(xcase0.s1) v(xcase0.s2) v(vdd0) i(vsupply81) v(xcase81.att_n0) v(xcase81.att_n1) v(xcase81.att_n2) v(xcase81.att_p0) v(xcase81.att_p1) v(xcase81.att_p2) v(cctrl81) v(cm81) v(xcase81.inn) v(xcase81.inp) v(inx81) v(iny81) v(xcase81.nbias) v(outn81) v(outp81) v(xcase81.p_bias) v(rctrl81) v(xcase81.s1) v(xcase81.s2) v(vdd81)
ac dec 50 1meg 100g
wrdata ac_372.txt v(outp0) v(outn0) v(vid0) v(outp81) v(outn81) v(vid81)
alter Vr0 1.476
alter Vc0 0.432
op
wrdata op_373.txt i(vsupply0) v(xcase0.att_n0) v(xcase0.att_n1) v(xcase0.att_n2) v(xcase0.att_p0) v(xcase0.att_p1) v(xcase0.att_p2) v(cctrl0) v(cm0) v(xcase0.inn) v(xcase0.inp) v(inx0) v(iny0) v(xcase0.nbias) v(outn0) v(outp0) v(xcase0.p_bias) v(xcase0.rc_ct) v(xcase0.rc_gate) v(xcase0.rc_mid) v(rctrl0) v(xcase0.s1) v(xcase0.s2) v(vdd0) i(vsupply81) v(xcase81.att_n0) v(xcase81.att_n1) v(xcase81.att_n2) v(xcase81.att_p0) v(xcase81.att_p1) v(xcase81.att_p2) v(cctrl81) v(cm81) v(xcase81.inn) v(xcase81.inp) v(inx81) v(iny81) v(xcase81.nbias) v(outn81) v(outp81) v(xcase81.p_bias) v(rctrl81) v(xcase81.s1) v(xcase81.s2) v(vdd81)
ac dec 50 1meg 100g
wrdata ac_373.txt v(outp0) v(outn0) v(vid0) v(outp81) v(outn81) v(vid81)
alter Vr0 1.476
alter Vc0 0.459
op
wrdata op_374.txt i(vsupply0) v(xcase0.att_n0) v(xcase0.att_n1) v(xcase0.att_n2) v(xcase0.att_p0) v(xcase0.att_p1) v(xcase0.att_p2) v(cctrl0) v(cm0) v(xcase0.inn) v(xcase0.inp) v(inx0) v(iny0) v(xcase0.nbias) v(outn0) v(outp0) v(xcase0.p_bias) v(xcase0.rc_ct) v(xcase0.rc_gate) v(xcase0.rc_mid) v(rctrl0) v(xcase0.s1) v(xcase0.s2) v(vdd0) i(vsupply81) v(xcase81.att_n0) v(xcase81.att_n1) v(xcase81.att_n2) v(xcase81.att_p0) v(xcase81.att_p1) v(xcase81.att_p2) v(cctrl81) v(cm81) v(xcase81.inn) v(xcase81.inp) v(inx81) v(iny81) v(xcase81.nbias) v(outn81) v(outp81) v(xcase81.p_bias) v(rctrl81) v(xcase81.s1) v(xcase81.s2) v(vdd81)
ac dec 50 1meg 100g
wrdata ac_374.txt v(outp0) v(outn0) v(vid0) v(outp81) v(outn81) v(vid81)
alter Vr0 1.476
alter Vc0 0.486
op
wrdata op_375.txt i(vsupply0) v(xcase0.att_n0) v(xcase0.att_n1) v(xcase0.att_n2) v(xcase0.att_p0) v(xcase0.att_p1) v(xcase0.att_p2) v(cctrl0) v(cm0) v(xcase0.inn) v(xcase0.inp) v(inx0) v(iny0) v(xcase0.nbias) v(outn0) v(outp0) v(xcase0.p_bias) v(xcase0.rc_ct) v(xcase0.rc_gate) v(xcase0.rc_mid) v(rctrl0) v(xcase0.s1) v(xcase0.s2) v(vdd0) i(vsupply81) v(xcase81.att_n0) v(xcase81.att_n1) v(xcase81.att_n2) v(xcase81.att_p0) v(xcase81.att_p1) v(xcase81.att_p2) v(cctrl81) v(cm81) v(xcase81.inn) v(xcase81.inp) v(inx81) v(iny81) v(xcase81.nbias) v(outn81) v(outp81) v(xcase81.p_bias) v(rctrl81) v(xcase81.s1) v(xcase81.s2) v(vdd81)
ac dec 50 1meg 100g
wrdata ac_375.txt v(outp0) v(outn0) v(vid0) v(outp81) v(outn81) v(vid81)
alter Vr0 1.476
alter Vc0 0.513
op
wrdata op_376.txt i(vsupply0) v(xcase0.att_n0) v(xcase0.att_n1) v(xcase0.att_n2) v(xcase0.att_p0) v(xcase0.att_p1) v(xcase0.att_p2) v(cctrl0) v(cm0) v(xcase0.inn) v(xcase0.inp) v(inx0) v(iny0) v(xcase0.nbias) v(outn0) v(outp0) v(xcase0.p_bias) v(xcase0.rc_ct) v(xcase0.rc_gate) v(xcase0.rc_mid) v(rctrl0) v(xcase0.s1) v(xcase0.s2) v(vdd0) i(vsupply81) v(xcase81.att_n0) v(xcase81.att_n1) v(xcase81.att_n2) v(xcase81.att_p0) v(xcase81.att_p1) v(xcase81.att_p2) v(cctrl81) v(cm81) v(xcase81.inn) v(xcase81.inp) v(inx81) v(iny81) v(xcase81.nbias) v(outn81) v(outp81) v(xcase81.p_bias) v(rctrl81) v(xcase81.s1) v(xcase81.s2) v(vdd81)
ac dec 50 1meg 100g
wrdata ac_376.txt v(outp0) v(outn0) v(vid0) v(outp81) v(outn81) v(vid81)
alter Vr0 1.476
alter Vc0 0.54
op
wrdata op_377.txt i(vsupply0) v(xcase0.att_n0) v(xcase0.att_n1) v(xcase0.att_n2) v(xcase0.att_p0) v(xcase0.att_p1) v(xcase0.att_p2) v(cctrl0) v(cm0) v(xcase0.inn) v(xcase0.inp) v(inx0) v(iny0) v(xcase0.nbias) v(outn0) v(outp0) v(xcase0.p_bias) v(xcase0.rc_ct) v(xcase0.rc_gate) v(xcase0.rc_mid) v(rctrl0) v(xcase0.s1) v(xcase0.s2) v(vdd0) i(vsupply81) v(xcase81.att_n0) v(xcase81.att_n1) v(xcase81.att_n2) v(xcase81.att_p0) v(xcase81.att_p1) v(xcase81.att_p2) v(cctrl81) v(cm81) v(xcase81.inn) v(xcase81.inp) v(inx81) v(iny81) v(xcase81.nbias) v(outn81) v(outp81) v(xcase81.p_bias) v(rctrl81) v(xcase81.s1) v(xcase81.s2) v(vdd81)
ac dec 50 1meg 100g
wrdata ac_377.txt v(outp0) v(outn0) v(vid0) v(outp81) v(outn81) v(vid81)
alter Vr0 1.494
alter Vc0 0
op
wrdata op_378.txt i(vsupply0) v(xcase0.att_n0) v(xcase0.att_n1) v(xcase0.att_n2) v(xcase0.att_p0) v(xcase0.att_p1) v(xcase0.att_p2) v(cctrl0) v(cm0) v(xcase0.inn) v(xcase0.inp) v(inx0) v(iny0) v(xcase0.nbias) v(outn0) v(outp0) v(xcase0.p_bias) v(xcase0.rc_ct) v(xcase0.rc_gate) v(xcase0.rc_mid) v(rctrl0) v(xcase0.s1) v(xcase0.s2) v(vdd0) i(vsupply81) v(xcase81.att_n0) v(xcase81.att_n1) v(xcase81.att_n2) v(xcase81.att_p0) v(xcase81.att_p1) v(xcase81.att_p2) v(cctrl81) v(cm81) v(xcase81.inn) v(xcase81.inp) v(inx81) v(iny81) v(xcase81.nbias) v(outn81) v(outp81) v(xcase81.p_bias) v(rctrl81) v(xcase81.s1) v(xcase81.s2) v(vdd81)
ac dec 50 1meg 100g
wrdata ac_378.txt v(outp0) v(outn0) v(vid0) v(outp81) v(outn81) v(vid81)
alter Vr0 1.494
alter Vc0 0.027
op
wrdata op_379.txt i(vsupply0) v(xcase0.att_n0) v(xcase0.att_n1) v(xcase0.att_n2) v(xcase0.att_p0) v(xcase0.att_p1) v(xcase0.att_p2) v(cctrl0) v(cm0) v(xcase0.inn) v(xcase0.inp) v(inx0) v(iny0) v(xcase0.nbias) v(outn0) v(outp0) v(xcase0.p_bias) v(xcase0.rc_ct) v(xcase0.rc_gate) v(xcase0.rc_mid) v(rctrl0) v(xcase0.s1) v(xcase0.s2) v(vdd0) i(vsupply81) v(xcase81.att_n0) v(xcase81.att_n1) v(xcase81.att_n2) v(xcase81.att_p0) v(xcase81.att_p1) v(xcase81.att_p2) v(cctrl81) v(cm81) v(xcase81.inn) v(xcase81.inp) v(inx81) v(iny81) v(xcase81.nbias) v(outn81) v(outp81) v(xcase81.p_bias) v(rctrl81) v(xcase81.s1) v(xcase81.s2) v(vdd81)
ac dec 50 1meg 100g
wrdata ac_379.txt v(outp0) v(outn0) v(vid0) v(outp81) v(outn81) v(vid81)
alter Vr0 1.494
alter Vc0 0.054
op
wrdata op_380.txt i(vsupply0) v(xcase0.att_n0) v(xcase0.att_n1) v(xcase0.att_n2) v(xcase0.att_p0) v(xcase0.att_p1) v(xcase0.att_p2) v(cctrl0) v(cm0) v(xcase0.inn) v(xcase0.inp) v(inx0) v(iny0) v(xcase0.nbias) v(outn0) v(outp0) v(xcase0.p_bias) v(xcase0.rc_ct) v(xcase0.rc_gate) v(xcase0.rc_mid) v(rctrl0) v(xcase0.s1) v(xcase0.s2) v(vdd0) i(vsupply81) v(xcase81.att_n0) v(xcase81.att_n1) v(xcase81.att_n2) v(xcase81.att_p0) v(xcase81.att_p1) v(xcase81.att_p2) v(cctrl81) v(cm81) v(xcase81.inn) v(xcase81.inp) v(inx81) v(iny81) v(xcase81.nbias) v(outn81) v(outp81) v(xcase81.p_bias) v(rctrl81) v(xcase81.s1) v(xcase81.s2) v(vdd81)
ac dec 50 1meg 100g
wrdata ac_380.txt v(outp0) v(outn0) v(vid0) v(outp81) v(outn81) v(vid81)
alter Vr0 1.494
alter Vc0 0.081
op
wrdata op_381.txt i(vsupply0) v(xcase0.att_n0) v(xcase0.att_n1) v(xcase0.att_n2) v(xcase0.att_p0) v(xcase0.att_p1) v(xcase0.att_p2) v(cctrl0) v(cm0) v(xcase0.inn) v(xcase0.inp) v(inx0) v(iny0) v(xcase0.nbias) v(outn0) v(outp0) v(xcase0.p_bias) v(xcase0.rc_ct) v(xcase0.rc_gate) v(xcase0.rc_mid) v(rctrl0) v(xcase0.s1) v(xcase0.s2) v(vdd0) i(vsupply81) v(xcase81.att_n0) v(xcase81.att_n1) v(xcase81.att_n2) v(xcase81.att_p0) v(xcase81.att_p1) v(xcase81.att_p2) v(cctrl81) v(cm81) v(xcase81.inn) v(xcase81.inp) v(inx81) v(iny81) v(xcase81.nbias) v(outn81) v(outp81) v(xcase81.p_bias) v(rctrl81) v(xcase81.s1) v(xcase81.s2) v(vdd81)
ac dec 50 1meg 100g
wrdata ac_381.txt v(outp0) v(outn0) v(vid0) v(outp81) v(outn81) v(vid81)
alter Vr0 1.494
alter Vc0 0.108
op
wrdata op_382.txt i(vsupply0) v(xcase0.att_n0) v(xcase0.att_n1) v(xcase0.att_n2) v(xcase0.att_p0) v(xcase0.att_p1) v(xcase0.att_p2) v(cctrl0) v(cm0) v(xcase0.inn) v(xcase0.inp) v(inx0) v(iny0) v(xcase0.nbias) v(outn0) v(outp0) v(xcase0.p_bias) v(xcase0.rc_ct) v(xcase0.rc_gate) v(xcase0.rc_mid) v(rctrl0) v(xcase0.s1) v(xcase0.s2) v(vdd0) i(vsupply81) v(xcase81.att_n0) v(xcase81.att_n1) v(xcase81.att_n2) v(xcase81.att_p0) v(xcase81.att_p1) v(xcase81.att_p2) v(cctrl81) v(cm81) v(xcase81.inn) v(xcase81.inp) v(inx81) v(iny81) v(xcase81.nbias) v(outn81) v(outp81) v(xcase81.p_bias) v(rctrl81) v(xcase81.s1) v(xcase81.s2) v(vdd81)
ac dec 50 1meg 100g
wrdata ac_382.txt v(outp0) v(outn0) v(vid0) v(outp81) v(outn81) v(vid81)
alter Vr0 1.494
alter Vc0 0.135
op
wrdata op_383.txt i(vsupply0) v(xcase0.att_n0) v(xcase0.att_n1) v(xcase0.att_n2) v(xcase0.att_p0) v(xcase0.att_p1) v(xcase0.att_p2) v(cctrl0) v(cm0) v(xcase0.inn) v(xcase0.inp) v(inx0) v(iny0) v(xcase0.nbias) v(outn0) v(outp0) v(xcase0.p_bias) v(xcase0.rc_ct) v(xcase0.rc_gate) v(xcase0.rc_mid) v(rctrl0) v(xcase0.s1) v(xcase0.s2) v(vdd0) i(vsupply81) v(xcase81.att_n0) v(xcase81.att_n1) v(xcase81.att_n2) v(xcase81.att_p0) v(xcase81.att_p1) v(xcase81.att_p2) v(cctrl81) v(cm81) v(xcase81.inn) v(xcase81.inp) v(inx81) v(iny81) v(xcase81.nbias) v(outn81) v(outp81) v(xcase81.p_bias) v(rctrl81) v(xcase81.s1) v(xcase81.s2) v(vdd81)
ac dec 50 1meg 100g
wrdata ac_383.txt v(outp0) v(outn0) v(vid0) v(outp81) v(outn81) v(vid81)
alter Vr0 1.494
alter Vc0 0.162
op
wrdata op_384.txt i(vsupply0) v(xcase0.att_n0) v(xcase0.att_n1) v(xcase0.att_n2) v(xcase0.att_p0) v(xcase0.att_p1) v(xcase0.att_p2) v(cctrl0) v(cm0) v(xcase0.inn) v(xcase0.inp) v(inx0) v(iny0) v(xcase0.nbias) v(outn0) v(outp0) v(xcase0.p_bias) v(xcase0.rc_ct) v(xcase0.rc_gate) v(xcase0.rc_mid) v(rctrl0) v(xcase0.s1) v(xcase0.s2) v(vdd0) i(vsupply81) v(xcase81.att_n0) v(xcase81.att_n1) v(xcase81.att_n2) v(xcase81.att_p0) v(xcase81.att_p1) v(xcase81.att_p2) v(cctrl81) v(cm81) v(xcase81.inn) v(xcase81.inp) v(inx81) v(iny81) v(xcase81.nbias) v(outn81) v(outp81) v(xcase81.p_bias) v(rctrl81) v(xcase81.s1) v(xcase81.s2) v(vdd81)
ac dec 50 1meg 100g
wrdata ac_384.txt v(outp0) v(outn0) v(vid0) v(outp81) v(outn81) v(vid81)
alter Vr0 1.494
alter Vc0 0.189
op
wrdata op_385.txt i(vsupply0) v(xcase0.att_n0) v(xcase0.att_n1) v(xcase0.att_n2) v(xcase0.att_p0) v(xcase0.att_p1) v(xcase0.att_p2) v(cctrl0) v(cm0) v(xcase0.inn) v(xcase0.inp) v(inx0) v(iny0) v(xcase0.nbias) v(outn0) v(outp0) v(xcase0.p_bias) v(xcase0.rc_ct) v(xcase0.rc_gate) v(xcase0.rc_mid) v(rctrl0) v(xcase0.s1) v(xcase0.s2) v(vdd0) i(vsupply81) v(xcase81.att_n0) v(xcase81.att_n1) v(xcase81.att_n2) v(xcase81.att_p0) v(xcase81.att_p1) v(xcase81.att_p2) v(cctrl81) v(cm81) v(xcase81.inn) v(xcase81.inp) v(inx81) v(iny81) v(xcase81.nbias) v(outn81) v(outp81) v(xcase81.p_bias) v(rctrl81) v(xcase81.s1) v(xcase81.s2) v(vdd81)
ac dec 50 1meg 100g
wrdata ac_385.txt v(outp0) v(outn0) v(vid0) v(outp81) v(outn81) v(vid81)
alter Vr0 1.494
alter Vc0 0.216
op
wrdata op_386.txt i(vsupply0) v(xcase0.att_n0) v(xcase0.att_n1) v(xcase0.att_n2) v(xcase0.att_p0) v(xcase0.att_p1) v(xcase0.att_p2) v(cctrl0) v(cm0) v(xcase0.inn) v(xcase0.inp) v(inx0) v(iny0) v(xcase0.nbias) v(outn0) v(outp0) v(xcase0.p_bias) v(xcase0.rc_ct) v(xcase0.rc_gate) v(xcase0.rc_mid) v(rctrl0) v(xcase0.s1) v(xcase0.s2) v(vdd0) i(vsupply81) v(xcase81.att_n0) v(xcase81.att_n1) v(xcase81.att_n2) v(xcase81.att_p0) v(xcase81.att_p1) v(xcase81.att_p2) v(cctrl81) v(cm81) v(xcase81.inn) v(xcase81.inp) v(inx81) v(iny81) v(xcase81.nbias) v(outn81) v(outp81) v(xcase81.p_bias) v(rctrl81) v(xcase81.s1) v(xcase81.s2) v(vdd81)
ac dec 50 1meg 100g
wrdata ac_386.txt v(outp0) v(outn0) v(vid0) v(outp81) v(outn81) v(vid81)
alter Vr0 1.494
alter Vc0 0.243
op
wrdata op_387.txt i(vsupply0) v(xcase0.att_n0) v(xcase0.att_n1) v(xcase0.att_n2) v(xcase0.att_p0) v(xcase0.att_p1) v(xcase0.att_p2) v(cctrl0) v(cm0) v(xcase0.inn) v(xcase0.inp) v(inx0) v(iny0) v(xcase0.nbias) v(outn0) v(outp0) v(xcase0.p_bias) v(xcase0.rc_ct) v(xcase0.rc_gate) v(xcase0.rc_mid) v(rctrl0) v(xcase0.s1) v(xcase0.s2) v(vdd0) i(vsupply81) v(xcase81.att_n0) v(xcase81.att_n1) v(xcase81.att_n2) v(xcase81.att_p0) v(xcase81.att_p1) v(xcase81.att_p2) v(cctrl81) v(cm81) v(xcase81.inn) v(xcase81.inp) v(inx81) v(iny81) v(xcase81.nbias) v(outn81) v(outp81) v(xcase81.p_bias) v(rctrl81) v(xcase81.s1) v(xcase81.s2) v(vdd81)
ac dec 50 1meg 100g
wrdata ac_387.txt v(outp0) v(outn0) v(vid0) v(outp81) v(outn81) v(vid81)
alter Vr0 1.494
alter Vc0 0.27
op
wrdata op_388.txt i(vsupply0) v(xcase0.att_n0) v(xcase0.att_n1) v(xcase0.att_n2) v(xcase0.att_p0) v(xcase0.att_p1) v(xcase0.att_p2) v(cctrl0) v(cm0) v(xcase0.inn) v(xcase0.inp) v(inx0) v(iny0) v(xcase0.nbias) v(outn0) v(outp0) v(xcase0.p_bias) v(xcase0.rc_ct) v(xcase0.rc_gate) v(xcase0.rc_mid) v(rctrl0) v(xcase0.s1) v(xcase0.s2) v(vdd0) i(vsupply81) v(xcase81.att_n0) v(xcase81.att_n1) v(xcase81.att_n2) v(xcase81.att_p0) v(xcase81.att_p1) v(xcase81.att_p2) v(cctrl81) v(cm81) v(xcase81.inn) v(xcase81.inp) v(inx81) v(iny81) v(xcase81.nbias) v(outn81) v(outp81) v(xcase81.p_bias) v(rctrl81) v(xcase81.s1) v(xcase81.s2) v(vdd81)
ac dec 50 1meg 100g
wrdata ac_388.txt v(outp0) v(outn0) v(vid0) v(outp81) v(outn81) v(vid81)
alter Vr0 1.494
alter Vc0 0.297
op
wrdata op_389.txt i(vsupply0) v(xcase0.att_n0) v(xcase0.att_n1) v(xcase0.att_n2) v(xcase0.att_p0) v(xcase0.att_p1) v(xcase0.att_p2) v(cctrl0) v(cm0) v(xcase0.inn) v(xcase0.inp) v(inx0) v(iny0) v(xcase0.nbias) v(outn0) v(outp0) v(xcase0.p_bias) v(xcase0.rc_ct) v(xcase0.rc_gate) v(xcase0.rc_mid) v(rctrl0) v(xcase0.s1) v(xcase0.s2) v(vdd0) i(vsupply81) v(xcase81.att_n0) v(xcase81.att_n1) v(xcase81.att_n2) v(xcase81.att_p0) v(xcase81.att_p1) v(xcase81.att_p2) v(cctrl81) v(cm81) v(xcase81.inn) v(xcase81.inp) v(inx81) v(iny81) v(xcase81.nbias) v(outn81) v(outp81) v(xcase81.p_bias) v(rctrl81) v(xcase81.s1) v(xcase81.s2) v(vdd81)
ac dec 50 1meg 100g
wrdata ac_389.txt v(outp0) v(outn0) v(vid0) v(outp81) v(outn81) v(vid81)
alter Vr0 1.494
alter Vc0 0.324
op
wrdata op_390.txt i(vsupply0) v(xcase0.att_n0) v(xcase0.att_n1) v(xcase0.att_n2) v(xcase0.att_p0) v(xcase0.att_p1) v(xcase0.att_p2) v(cctrl0) v(cm0) v(xcase0.inn) v(xcase0.inp) v(inx0) v(iny0) v(xcase0.nbias) v(outn0) v(outp0) v(xcase0.p_bias) v(xcase0.rc_ct) v(xcase0.rc_gate) v(xcase0.rc_mid) v(rctrl0) v(xcase0.s1) v(xcase0.s2) v(vdd0) i(vsupply81) v(xcase81.att_n0) v(xcase81.att_n1) v(xcase81.att_n2) v(xcase81.att_p0) v(xcase81.att_p1) v(xcase81.att_p2) v(cctrl81) v(cm81) v(xcase81.inn) v(xcase81.inp) v(inx81) v(iny81) v(xcase81.nbias) v(outn81) v(outp81) v(xcase81.p_bias) v(rctrl81) v(xcase81.s1) v(xcase81.s2) v(vdd81)
ac dec 50 1meg 100g
wrdata ac_390.txt v(outp0) v(outn0) v(vid0) v(outp81) v(outn81) v(vid81)
alter Vr0 1.494
alter Vc0 0.351
op
wrdata op_391.txt i(vsupply0) v(xcase0.att_n0) v(xcase0.att_n1) v(xcase0.att_n2) v(xcase0.att_p0) v(xcase0.att_p1) v(xcase0.att_p2) v(cctrl0) v(cm0) v(xcase0.inn) v(xcase0.inp) v(inx0) v(iny0) v(xcase0.nbias) v(outn0) v(outp0) v(xcase0.p_bias) v(xcase0.rc_ct) v(xcase0.rc_gate) v(xcase0.rc_mid) v(rctrl0) v(xcase0.s1) v(xcase0.s2) v(vdd0) i(vsupply81) v(xcase81.att_n0) v(xcase81.att_n1) v(xcase81.att_n2) v(xcase81.att_p0) v(xcase81.att_p1) v(xcase81.att_p2) v(cctrl81) v(cm81) v(xcase81.inn) v(xcase81.inp) v(inx81) v(iny81) v(xcase81.nbias) v(outn81) v(outp81) v(xcase81.p_bias) v(rctrl81) v(xcase81.s1) v(xcase81.s2) v(vdd81)
ac dec 50 1meg 100g
wrdata ac_391.txt v(outp0) v(outn0) v(vid0) v(outp81) v(outn81) v(vid81)
alter Vr0 1.494
alter Vc0 0.378
op
wrdata op_392.txt i(vsupply0) v(xcase0.att_n0) v(xcase0.att_n1) v(xcase0.att_n2) v(xcase0.att_p0) v(xcase0.att_p1) v(xcase0.att_p2) v(cctrl0) v(cm0) v(xcase0.inn) v(xcase0.inp) v(inx0) v(iny0) v(xcase0.nbias) v(outn0) v(outp0) v(xcase0.p_bias) v(xcase0.rc_ct) v(xcase0.rc_gate) v(xcase0.rc_mid) v(rctrl0) v(xcase0.s1) v(xcase0.s2) v(vdd0) i(vsupply81) v(xcase81.att_n0) v(xcase81.att_n1) v(xcase81.att_n2) v(xcase81.att_p0) v(xcase81.att_p1) v(xcase81.att_p2) v(cctrl81) v(cm81) v(xcase81.inn) v(xcase81.inp) v(inx81) v(iny81) v(xcase81.nbias) v(outn81) v(outp81) v(xcase81.p_bias) v(rctrl81) v(xcase81.s1) v(xcase81.s2) v(vdd81)
ac dec 50 1meg 100g
wrdata ac_392.txt v(outp0) v(outn0) v(vid0) v(outp81) v(outn81) v(vid81)
alter Vr0 1.494
alter Vc0 0.405
op
wrdata op_393.txt i(vsupply0) v(xcase0.att_n0) v(xcase0.att_n1) v(xcase0.att_n2) v(xcase0.att_p0) v(xcase0.att_p1) v(xcase0.att_p2) v(cctrl0) v(cm0) v(xcase0.inn) v(xcase0.inp) v(inx0) v(iny0) v(xcase0.nbias) v(outn0) v(outp0) v(xcase0.p_bias) v(xcase0.rc_ct) v(xcase0.rc_gate) v(xcase0.rc_mid) v(rctrl0) v(xcase0.s1) v(xcase0.s2) v(vdd0) i(vsupply81) v(xcase81.att_n0) v(xcase81.att_n1) v(xcase81.att_n2) v(xcase81.att_p0) v(xcase81.att_p1) v(xcase81.att_p2) v(cctrl81) v(cm81) v(xcase81.inn) v(xcase81.inp) v(inx81) v(iny81) v(xcase81.nbias) v(outn81) v(outp81) v(xcase81.p_bias) v(rctrl81) v(xcase81.s1) v(xcase81.s2) v(vdd81)
ac dec 50 1meg 100g
wrdata ac_393.txt v(outp0) v(outn0) v(vid0) v(outp81) v(outn81) v(vid81)
alter Vr0 1.494
alter Vc0 0.432
op
wrdata op_394.txt i(vsupply0) v(xcase0.att_n0) v(xcase0.att_n1) v(xcase0.att_n2) v(xcase0.att_p0) v(xcase0.att_p1) v(xcase0.att_p2) v(cctrl0) v(cm0) v(xcase0.inn) v(xcase0.inp) v(inx0) v(iny0) v(xcase0.nbias) v(outn0) v(outp0) v(xcase0.p_bias) v(xcase0.rc_ct) v(xcase0.rc_gate) v(xcase0.rc_mid) v(rctrl0) v(xcase0.s1) v(xcase0.s2) v(vdd0) i(vsupply81) v(xcase81.att_n0) v(xcase81.att_n1) v(xcase81.att_n2) v(xcase81.att_p0) v(xcase81.att_p1) v(xcase81.att_p2) v(cctrl81) v(cm81) v(xcase81.inn) v(xcase81.inp) v(inx81) v(iny81) v(xcase81.nbias) v(outn81) v(outp81) v(xcase81.p_bias) v(rctrl81) v(xcase81.s1) v(xcase81.s2) v(vdd81)
ac dec 50 1meg 100g
wrdata ac_394.txt v(outp0) v(outn0) v(vid0) v(outp81) v(outn81) v(vid81)
alter Vr0 1.494
alter Vc0 0.459
op
wrdata op_395.txt i(vsupply0) v(xcase0.att_n0) v(xcase0.att_n1) v(xcase0.att_n2) v(xcase0.att_p0) v(xcase0.att_p1) v(xcase0.att_p2) v(cctrl0) v(cm0) v(xcase0.inn) v(xcase0.inp) v(inx0) v(iny0) v(xcase0.nbias) v(outn0) v(outp0) v(xcase0.p_bias) v(xcase0.rc_ct) v(xcase0.rc_gate) v(xcase0.rc_mid) v(rctrl0) v(xcase0.s1) v(xcase0.s2) v(vdd0) i(vsupply81) v(xcase81.att_n0) v(xcase81.att_n1) v(xcase81.att_n2) v(xcase81.att_p0) v(xcase81.att_p1) v(xcase81.att_p2) v(cctrl81) v(cm81) v(xcase81.inn) v(xcase81.inp) v(inx81) v(iny81) v(xcase81.nbias) v(outn81) v(outp81) v(xcase81.p_bias) v(rctrl81) v(xcase81.s1) v(xcase81.s2) v(vdd81)
ac dec 50 1meg 100g
wrdata ac_395.txt v(outp0) v(outn0) v(vid0) v(outp81) v(outn81) v(vid81)
alter Vr0 1.494
alter Vc0 0.486
op
wrdata op_396.txt i(vsupply0) v(xcase0.att_n0) v(xcase0.att_n1) v(xcase0.att_n2) v(xcase0.att_p0) v(xcase0.att_p1) v(xcase0.att_p2) v(cctrl0) v(cm0) v(xcase0.inn) v(xcase0.inp) v(inx0) v(iny0) v(xcase0.nbias) v(outn0) v(outp0) v(xcase0.p_bias) v(xcase0.rc_ct) v(xcase0.rc_gate) v(xcase0.rc_mid) v(rctrl0) v(xcase0.s1) v(xcase0.s2) v(vdd0) i(vsupply81) v(xcase81.att_n0) v(xcase81.att_n1) v(xcase81.att_n2) v(xcase81.att_p0) v(xcase81.att_p1) v(xcase81.att_p2) v(cctrl81) v(cm81) v(xcase81.inn) v(xcase81.inp) v(inx81) v(iny81) v(xcase81.nbias) v(outn81) v(outp81) v(xcase81.p_bias) v(rctrl81) v(xcase81.s1) v(xcase81.s2) v(vdd81)
ac dec 50 1meg 100g
wrdata ac_396.txt v(outp0) v(outn0) v(vid0) v(outp81) v(outn81) v(vid81)
alter Vr0 1.494
alter Vc0 0.513
op
wrdata op_397.txt i(vsupply0) v(xcase0.att_n0) v(xcase0.att_n1) v(xcase0.att_n2) v(xcase0.att_p0) v(xcase0.att_p1) v(xcase0.att_p2) v(cctrl0) v(cm0) v(xcase0.inn) v(xcase0.inp) v(inx0) v(iny0) v(xcase0.nbias) v(outn0) v(outp0) v(xcase0.p_bias) v(xcase0.rc_ct) v(xcase0.rc_gate) v(xcase0.rc_mid) v(rctrl0) v(xcase0.s1) v(xcase0.s2) v(vdd0) i(vsupply81) v(xcase81.att_n0) v(xcase81.att_n1) v(xcase81.att_n2) v(xcase81.att_p0) v(xcase81.att_p1) v(xcase81.att_p2) v(cctrl81) v(cm81) v(xcase81.inn) v(xcase81.inp) v(inx81) v(iny81) v(xcase81.nbias) v(outn81) v(outp81) v(xcase81.p_bias) v(rctrl81) v(xcase81.s1) v(xcase81.s2) v(vdd81)
ac dec 50 1meg 100g
wrdata ac_397.txt v(outp0) v(outn0) v(vid0) v(outp81) v(outn81) v(vid81)
alter Vr0 1.494
alter Vc0 0.54
op
wrdata op_398.txt i(vsupply0) v(xcase0.att_n0) v(xcase0.att_n1) v(xcase0.att_n2) v(xcase0.att_p0) v(xcase0.att_p1) v(xcase0.att_p2) v(cctrl0) v(cm0) v(xcase0.inn) v(xcase0.inp) v(inx0) v(iny0) v(xcase0.nbias) v(outn0) v(outp0) v(xcase0.p_bias) v(xcase0.rc_ct) v(xcase0.rc_gate) v(xcase0.rc_mid) v(rctrl0) v(xcase0.s1) v(xcase0.s2) v(vdd0) i(vsupply81) v(xcase81.att_n0) v(xcase81.att_n1) v(xcase81.att_n2) v(xcase81.att_p0) v(xcase81.att_p1) v(xcase81.att_p2) v(cctrl81) v(cm81) v(xcase81.inn) v(xcase81.inp) v(inx81) v(iny81) v(xcase81.nbias) v(outn81) v(outp81) v(xcase81.p_bias) v(rctrl81) v(xcase81.s1) v(xcase81.s2) v(vdd81)
ac dec 50 1meg 100g
wrdata ac_398.txt v(outp0) v(outn0) v(vid0) v(outp81) v(outn81) v(vid81)
alter Vr0 1.512
alter Vc0 0
op
wrdata op_399.txt i(vsupply0) v(xcase0.att_n0) v(xcase0.att_n1) v(xcase0.att_n2) v(xcase0.att_p0) v(xcase0.att_p1) v(xcase0.att_p2) v(cctrl0) v(cm0) v(xcase0.inn) v(xcase0.inp) v(inx0) v(iny0) v(xcase0.nbias) v(outn0) v(outp0) v(xcase0.p_bias) v(xcase0.rc_ct) v(xcase0.rc_gate) v(xcase0.rc_mid) v(rctrl0) v(xcase0.s1) v(xcase0.s2) v(vdd0) i(vsupply81) v(xcase81.att_n0) v(xcase81.att_n1) v(xcase81.att_n2) v(xcase81.att_p0) v(xcase81.att_p1) v(xcase81.att_p2) v(cctrl81) v(cm81) v(xcase81.inn) v(xcase81.inp) v(inx81) v(iny81) v(xcase81.nbias) v(outn81) v(outp81) v(xcase81.p_bias) v(rctrl81) v(xcase81.s1) v(xcase81.s2) v(vdd81)
ac dec 50 1meg 100g
wrdata ac_399.txt v(outp0) v(outn0) v(vid0) v(outp81) v(outn81) v(vid81)
alter Vr0 1.512
alter Vc0 0.027
op
wrdata op_400.txt i(vsupply0) v(xcase0.att_n0) v(xcase0.att_n1) v(xcase0.att_n2) v(xcase0.att_p0) v(xcase0.att_p1) v(xcase0.att_p2) v(cctrl0) v(cm0) v(xcase0.inn) v(xcase0.inp) v(inx0) v(iny0) v(xcase0.nbias) v(outn0) v(outp0) v(xcase0.p_bias) v(xcase0.rc_ct) v(xcase0.rc_gate) v(xcase0.rc_mid) v(rctrl0) v(xcase0.s1) v(xcase0.s2) v(vdd0) i(vsupply81) v(xcase81.att_n0) v(xcase81.att_n1) v(xcase81.att_n2) v(xcase81.att_p0) v(xcase81.att_p1) v(xcase81.att_p2) v(cctrl81) v(cm81) v(xcase81.inn) v(xcase81.inp) v(inx81) v(iny81) v(xcase81.nbias) v(outn81) v(outp81) v(xcase81.p_bias) v(rctrl81) v(xcase81.s1) v(xcase81.s2) v(vdd81)
ac dec 50 1meg 100g
wrdata ac_400.txt v(outp0) v(outn0) v(vid0) v(outp81) v(outn81) v(vid81)
alter Vr0 1.512
alter Vc0 0.054
op
wrdata op_401.txt i(vsupply0) v(xcase0.att_n0) v(xcase0.att_n1) v(xcase0.att_n2) v(xcase0.att_p0) v(xcase0.att_p1) v(xcase0.att_p2) v(cctrl0) v(cm0) v(xcase0.inn) v(xcase0.inp) v(inx0) v(iny0) v(xcase0.nbias) v(outn0) v(outp0) v(xcase0.p_bias) v(xcase0.rc_ct) v(xcase0.rc_gate) v(xcase0.rc_mid) v(rctrl0) v(xcase0.s1) v(xcase0.s2) v(vdd0) i(vsupply81) v(xcase81.att_n0) v(xcase81.att_n1) v(xcase81.att_n2) v(xcase81.att_p0) v(xcase81.att_p1) v(xcase81.att_p2) v(cctrl81) v(cm81) v(xcase81.inn) v(xcase81.inp) v(inx81) v(iny81) v(xcase81.nbias) v(outn81) v(outp81) v(xcase81.p_bias) v(rctrl81) v(xcase81.s1) v(xcase81.s2) v(vdd81)
ac dec 50 1meg 100g
wrdata ac_401.txt v(outp0) v(outn0) v(vid0) v(outp81) v(outn81) v(vid81)
alter Vr0 1.512
alter Vc0 0.081
op
wrdata op_402.txt i(vsupply0) v(xcase0.att_n0) v(xcase0.att_n1) v(xcase0.att_n2) v(xcase0.att_p0) v(xcase0.att_p1) v(xcase0.att_p2) v(cctrl0) v(cm0) v(xcase0.inn) v(xcase0.inp) v(inx0) v(iny0) v(xcase0.nbias) v(outn0) v(outp0) v(xcase0.p_bias) v(xcase0.rc_ct) v(xcase0.rc_gate) v(xcase0.rc_mid) v(rctrl0) v(xcase0.s1) v(xcase0.s2) v(vdd0) i(vsupply81) v(xcase81.att_n0) v(xcase81.att_n1) v(xcase81.att_n2) v(xcase81.att_p0) v(xcase81.att_p1) v(xcase81.att_p2) v(cctrl81) v(cm81) v(xcase81.inn) v(xcase81.inp) v(inx81) v(iny81) v(xcase81.nbias) v(outn81) v(outp81) v(xcase81.p_bias) v(rctrl81) v(xcase81.s1) v(xcase81.s2) v(vdd81)
ac dec 50 1meg 100g
wrdata ac_402.txt v(outp0) v(outn0) v(vid0) v(outp81) v(outn81) v(vid81)
alter Vr0 1.512
alter Vc0 0.108
op
wrdata op_403.txt i(vsupply0) v(xcase0.att_n0) v(xcase0.att_n1) v(xcase0.att_n2) v(xcase0.att_p0) v(xcase0.att_p1) v(xcase0.att_p2) v(cctrl0) v(cm0) v(xcase0.inn) v(xcase0.inp) v(inx0) v(iny0) v(xcase0.nbias) v(outn0) v(outp0) v(xcase0.p_bias) v(xcase0.rc_ct) v(xcase0.rc_gate) v(xcase0.rc_mid) v(rctrl0) v(xcase0.s1) v(xcase0.s2) v(vdd0) i(vsupply81) v(xcase81.att_n0) v(xcase81.att_n1) v(xcase81.att_n2) v(xcase81.att_p0) v(xcase81.att_p1) v(xcase81.att_p2) v(cctrl81) v(cm81) v(xcase81.inn) v(xcase81.inp) v(inx81) v(iny81) v(xcase81.nbias) v(outn81) v(outp81) v(xcase81.p_bias) v(rctrl81) v(xcase81.s1) v(xcase81.s2) v(vdd81)
ac dec 50 1meg 100g
wrdata ac_403.txt v(outp0) v(outn0) v(vid0) v(outp81) v(outn81) v(vid81)
alter Vr0 1.512
alter Vc0 0.135
op
wrdata op_404.txt i(vsupply0) v(xcase0.att_n0) v(xcase0.att_n1) v(xcase0.att_n2) v(xcase0.att_p0) v(xcase0.att_p1) v(xcase0.att_p2) v(cctrl0) v(cm0) v(xcase0.inn) v(xcase0.inp) v(inx0) v(iny0) v(xcase0.nbias) v(outn0) v(outp0) v(xcase0.p_bias) v(xcase0.rc_ct) v(xcase0.rc_gate) v(xcase0.rc_mid) v(rctrl0) v(xcase0.s1) v(xcase0.s2) v(vdd0) i(vsupply81) v(xcase81.att_n0) v(xcase81.att_n1) v(xcase81.att_n2) v(xcase81.att_p0) v(xcase81.att_p1) v(xcase81.att_p2) v(cctrl81) v(cm81) v(xcase81.inn) v(xcase81.inp) v(inx81) v(iny81) v(xcase81.nbias) v(outn81) v(outp81) v(xcase81.p_bias) v(rctrl81) v(xcase81.s1) v(xcase81.s2) v(vdd81)
ac dec 50 1meg 100g
wrdata ac_404.txt v(outp0) v(outn0) v(vid0) v(outp81) v(outn81) v(vid81)
alter Vr0 1.512
alter Vc0 0.162
op
wrdata op_405.txt i(vsupply0) v(xcase0.att_n0) v(xcase0.att_n1) v(xcase0.att_n2) v(xcase0.att_p0) v(xcase0.att_p1) v(xcase0.att_p2) v(cctrl0) v(cm0) v(xcase0.inn) v(xcase0.inp) v(inx0) v(iny0) v(xcase0.nbias) v(outn0) v(outp0) v(xcase0.p_bias) v(xcase0.rc_ct) v(xcase0.rc_gate) v(xcase0.rc_mid) v(rctrl0) v(xcase0.s1) v(xcase0.s2) v(vdd0) i(vsupply81) v(xcase81.att_n0) v(xcase81.att_n1) v(xcase81.att_n2) v(xcase81.att_p0) v(xcase81.att_p1) v(xcase81.att_p2) v(cctrl81) v(cm81) v(xcase81.inn) v(xcase81.inp) v(inx81) v(iny81) v(xcase81.nbias) v(outn81) v(outp81) v(xcase81.p_bias) v(rctrl81) v(xcase81.s1) v(xcase81.s2) v(vdd81)
ac dec 50 1meg 100g
wrdata ac_405.txt v(outp0) v(outn0) v(vid0) v(outp81) v(outn81) v(vid81)
alter Vr0 1.512
alter Vc0 0.189
op
wrdata op_406.txt i(vsupply0) v(xcase0.att_n0) v(xcase0.att_n1) v(xcase0.att_n2) v(xcase0.att_p0) v(xcase0.att_p1) v(xcase0.att_p2) v(cctrl0) v(cm0) v(xcase0.inn) v(xcase0.inp) v(inx0) v(iny0) v(xcase0.nbias) v(outn0) v(outp0) v(xcase0.p_bias) v(xcase0.rc_ct) v(xcase0.rc_gate) v(xcase0.rc_mid) v(rctrl0) v(xcase0.s1) v(xcase0.s2) v(vdd0) i(vsupply81) v(xcase81.att_n0) v(xcase81.att_n1) v(xcase81.att_n2) v(xcase81.att_p0) v(xcase81.att_p1) v(xcase81.att_p2) v(cctrl81) v(cm81) v(xcase81.inn) v(xcase81.inp) v(inx81) v(iny81) v(xcase81.nbias) v(outn81) v(outp81) v(xcase81.p_bias) v(rctrl81) v(xcase81.s1) v(xcase81.s2) v(vdd81)
ac dec 50 1meg 100g
wrdata ac_406.txt v(outp0) v(outn0) v(vid0) v(outp81) v(outn81) v(vid81)
alter Vr0 1.512
alter Vc0 0.216
op
wrdata op_407.txt i(vsupply0) v(xcase0.att_n0) v(xcase0.att_n1) v(xcase0.att_n2) v(xcase0.att_p0) v(xcase0.att_p1) v(xcase0.att_p2) v(cctrl0) v(cm0) v(xcase0.inn) v(xcase0.inp) v(inx0) v(iny0) v(xcase0.nbias) v(outn0) v(outp0) v(xcase0.p_bias) v(xcase0.rc_ct) v(xcase0.rc_gate) v(xcase0.rc_mid) v(rctrl0) v(xcase0.s1) v(xcase0.s2) v(vdd0) i(vsupply81) v(xcase81.att_n0) v(xcase81.att_n1) v(xcase81.att_n2) v(xcase81.att_p0) v(xcase81.att_p1) v(xcase81.att_p2) v(cctrl81) v(cm81) v(xcase81.inn) v(xcase81.inp) v(inx81) v(iny81) v(xcase81.nbias) v(outn81) v(outp81) v(xcase81.p_bias) v(rctrl81) v(xcase81.s1) v(xcase81.s2) v(vdd81)
ac dec 50 1meg 100g
wrdata ac_407.txt v(outp0) v(outn0) v(vid0) v(outp81) v(outn81) v(vid81)
alter Vr0 1.512
alter Vc0 0.243
op
wrdata op_408.txt i(vsupply0) v(xcase0.att_n0) v(xcase0.att_n1) v(xcase0.att_n2) v(xcase0.att_p0) v(xcase0.att_p1) v(xcase0.att_p2) v(cctrl0) v(cm0) v(xcase0.inn) v(xcase0.inp) v(inx0) v(iny0) v(xcase0.nbias) v(outn0) v(outp0) v(xcase0.p_bias) v(xcase0.rc_ct) v(xcase0.rc_gate) v(xcase0.rc_mid) v(rctrl0) v(xcase0.s1) v(xcase0.s2) v(vdd0) i(vsupply81) v(xcase81.att_n0) v(xcase81.att_n1) v(xcase81.att_n2) v(xcase81.att_p0) v(xcase81.att_p1) v(xcase81.att_p2) v(cctrl81) v(cm81) v(xcase81.inn) v(xcase81.inp) v(inx81) v(iny81) v(xcase81.nbias) v(outn81) v(outp81) v(xcase81.p_bias) v(rctrl81) v(xcase81.s1) v(xcase81.s2) v(vdd81)
ac dec 50 1meg 100g
wrdata ac_408.txt v(outp0) v(outn0) v(vid0) v(outp81) v(outn81) v(vid81)
alter Vr0 1.512
alter Vc0 0.27
op
wrdata op_409.txt i(vsupply0) v(xcase0.att_n0) v(xcase0.att_n1) v(xcase0.att_n2) v(xcase0.att_p0) v(xcase0.att_p1) v(xcase0.att_p2) v(cctrl0) v(cm0) v(xcase0.inn) v(xcase0.inp) v(inx0) v(iny0) v(xcase0.nbias) v(outn0) v(outp0) v(xcase0.p_bias) v(xcase0.rc_ct) v(xcase0.rc_gate) v(xcase0.rc_mid) v(rctrl0) v(xcase0.s1) v(xcase0.s2) v(vdd0) i(vsupply81) v(xcase81.att_n0) v(xcase81.att_n1) v(xcase81.att_n2) v(xcase81.att_p0) v(xcase81.att_p1) v(xcase81.att_p2) v(cctrl81) v(cm81) v(xcase81.inn) v(xcase81.inp) v(inx81) v(iny81) v(xcase81.nbias) v(outn81) v(outp81) v(xcase81.p_bias) v(rctrl81) v(xcase81.s1) v(xcase81.s2) v(vdd81)
ac dec 50 1meg 100g
wrdata ac_409.txt v(outp0) v(outn0) v(vid0) v(outp81) v(outn81) v(vid81)
alter Vr0 1.512
alter Vc0 0.297
op
wrdata op_410.txt i(vsupply0) v(xcase0.att_n0) v(xcase0.att_n1) v(xcase0.att_n2) v(xcase0.att_p0) v(xcase0.att_p1) v(xcase0.att_p2) v(cctrl0) v(cm0) v(xcase0.inn) v(xcase0.inp) v(inx0) v(iny0) v(xcase0.nbias) v(outn0) v(outp0) v(xcase0.p_bias) v(xcase0.rc_ct) v(xcase0.rc_gate) v(xcase0.rc_mid) v(rctrl0) v(xcase0.s1) v(xcase0.s2) v(vdd0) i(vsupply81) v(xcase81.att_n0) v(xcase81.att_n1) v(xcase81.att_n2) v(xcase81.att_p0) v(xcase81.att_p1) v(xcase81.att_p2) v(cctrl81) v(cm81) v(xcase81.inn) v(xcase81.inp) v(inx81) v(iny81) v(xcase81.nbias) v(outn81) v(outp81) v(xcase81.p_bias) v(rctrl81) v(xcase81.s1) v(xcase81.s2) v(vdd81)
ac dec 50 1meg 100g
wrdata ac_410.txt v(outp0) v(outn0) v(vid0) v(outp81) v(outn81) v(vid81)
alter Vr0 1.512
alter Vc0 0.324
op
wrdata op_411.txt i(vsupply0) v(xcase0.att_n0) v(xcase0.att_n1) v(xcase0.att_n2) v(xcase0.att_p0) v(xcase0.att_p1) v(xcase0.att_p2) v(cctrl0) v(cm0) v(xcase0.inn) v(xcase0.inp) v(inx0) v(iny0) v(xcase0.nbias) v(outn0) v(outp0) v(xcase0.p_bias) v(xcase0.rc_ct) v(xcase0.rc_gate) v(xcase0.rc_mid) v(rctrl0) v(xcase0.s1) v(xcase0.s2) v(vdd0) i(vsupply81) v(xcase81.att_n0) v(xcase81.att_n1) v(xcase81.att_n2) v(xcase81.att_p0) v(xcase81.att_p1) v(xcase81.att_p2) v(cctrl81) v(cm81) v(xcase81.inn) v(xcase81.inp) v(inx81) v(iny81) v(xcase81.nbias) v(outn81) v(outp81) v(xcase81.p_bias) v(rctrl81) v(xcase81.s1) v(xcase81.s2) v(vdd81)
ac dec 50 1meg 100g
wrdata ac_411.txt v(outp0) v(outn0) v(vid0) v(outp81) v(outn81) v(vid81)
alter Vr0 1.512
alter Vc0 0.351
op
wrdata op_412.txt i(vsupply0) v(xcase0.att_n0) v(xcase0.att_n1) v(xcase0.att_n2) v(xcase0.att_p0) v(xcase0.att_p1) v(xcase0.att_p2) v(cctrl0) v(cm0) v(xcase0.inn) v(xcase0.inp) v(inx0) v(iny0) v(xcase0.nbias) v(outn0) v(outp0) v(xcase0.p_bias) v(xcase0.rc_ct) v(xcase0.rc_gate) v(xcase0.rc_mid) v(rctrl0) v(xcase0.s1) v(xcase0.s2) v(vdd0) i(vsupply81) v(xcase81.att_n0) v(xcase81.att_n1) v(xcase81.att_n2) v(xcase81.att_p0) v(xcase81.att_p1) v(xcase81.att_p2) v(cctrl81) v(cm81) v(xcase81.inn) v(xcase81.inp) v(inx81) v(iny81) v(xcase81.nbias) v(outn81) v(outp81) v(xcase81.p_bias) v(rctrl81) v(xcase81.s1) v(xcase81.s2) v(vdd81)
ac dec 50 1meg 100g
wrdata ac_412.txt v(outp0) v(outn0) v(vid0) v(outp81) v(outn81) v(vid81)
alter Vr0 1.512
alter Vc0 0.378
op
wrdata op_413.txt i(vsupply0) v(xcase0.att_n0) v(xcase0.att_n1) v(xcase0.att_n2) v(xcase0.att_p0) v(xcase0.att_p1) v(xcase0.att_p2) v(cctrl0) v(cm0) v(xcase0.inn) v(xcase0.inp) v(inx0) v(iny0) v(xcase0.nbias) v(outn0) v(outp0) v(xcase0.p_bias) v(xcase0.rc_ct) v(xcase0.rc_gate) v(xcase0.rc_mid) v(rctrl0) v(xcase0.s1) v(xcase0.s2) v(vdd0) i(vsupply81) v(xcase81.att_n0) v(xcase81.att_n1) v(xcase81.att_n2) v(xcase81.att_p0) v(xcase81.att_p1) v(xcase81.att_p2) v(cctrl81) v(cm81) v(xcase81.inn) v(xcase81.inp) v(inx81) v(iny81) v(xcase81.nbias) v(outn81) v(outp81) v(xcase81.p_bias) v(rctrl81) v(xcase81.s1) v(xcase81.s2) v(vdd81)
ac dec 50 1meg 100g
wrdata ac_413.txt v(outp0) v(outn0) v(vid0) v(outp81) v(outn81) v(vid81)
alter Vr0 1.512
alter Vc0 0.405
op
wrdata op_414.txt i(vsupply0) v(xcase0.att_n0) v(xcase0.att_n1) v(xcase0.att_n2) v(xcase0.att_p0) v(xcase0.att_p1) v(xcase0.att_p2) v(cctrl0) v(cm0) v(xcase0.inn) v(xcase0.inp) v(inx0) v(iny0) v(xcase0.nbias) v(outn0) v(outp0) v(xcase0.p_bias) v(xcase0.rc_ct) v(xcase0.rc_gate) v(xcase0.rc_mid) v(rctrl0) v(xcase0.s1) v(xcase0.s2) v(vdd0) i(vsupply81) v(xcase81.att_n0) v(xcase81.att_n1) v(xcase81.att_n2) v(xcase81.att_p0) v(xcase81.att_p1) v(xcase81.att_p2) v(cctrl81) v(cm81) v(xcase81.inn) v(xcase81.inp) v(inx81) v(iny81) v(xcase81.nbias) v(outn81) v(outp81) v(xcase81.p_bias) v(rctrl81) v(xcase81.s1) v(xcase81.s2) v(vdd81)
ac dec 50 1meg 100g
wrdata ac_414.txt v(outp0) v(outn0) v(vid0) v(outp81) v(outn81) v(vid81)
alter Vr0 1.512
alter Vc0 0.432
op
wrdata op_415.txt i(vsupply0) v(xcase0.att_n0) v(xcase0.att_n1) v(xcase0.att_n2) v(xcase0.att_p0) v(xcase0.att_p1) v(xcase0.att_p2) v(cctrl0) v(cm0) v(xcase0.inn) v(xcase0.inp) v(inx0) v(iny0) v(xcase0.nbias) v(outn0) v(outp0) v(xcase0.p_bias) v(xcase0.rc_ct) v(xcase0.rc_gate) v(xcase0.rc_mid) v(rctrl0) v(xcase0.s1) v(xcase0.s2) v(vdd0) i(vsupply81) v(xcase81.att_n0) v(xcase81.att_n1) v(xcase81.att_n2) v(xcase81.att_p0) v(xcase81.att_p1) v(xcase81.att_p2) v(cctrl81) v(cm81) v(xcase81.inn) v(xcase81.inp) v(inx81) v(iny81) v(xcase81.nbias) v(outn81) v(outp81) v(xcase81.p_bias) v(rctrl81) v(xcase81.s1) v(xcase81.s2) v(vdd81)
ac dec 50 1meg 100g
wrdata ac_415.txt v(outp0) v(outn0) v(vid0) v(outp81) v(outn81) v(vid81)
alter Vr0 1.512
alter Vc0 0.459
op
wrdata op_416.txt i(vsupply0) v(xcase0.att_n0) v(xcase0.att_n1) v(xcase0.att_n2) v(xcase0.att_p0) v(xcase0.att_p1) v(xcase0.att_p2) v(cctrl0) v(cm0) v(xcase0.inn) v(xcase0.inp) v(inx0) v(iny0) v(xcase0.nbias) v(outn0) v(outp0) v(xcase0.p_bias) v(xcase0.rc_ct) v(xcase0.rc_gate) v(xcase0.rc_mid) v(rctrl0) v(xcase0.s1) v(xcase0.s2) v(vdd0) i(vsupply81) v(xcase81.att_n0) v(xcase81.att_n1) v(xcase81.att_n2) v(xcase81.att_p0) v(xcase81.att_p1) v(xcase81.att_p2) v(cctrl81) v(cm81) v(xcase81.inn) v(xcase81.inp) v(inx81) v(iny81) v(xcase81.nbias) v(outn81) v(outp81) v(xcase81.p_bias) v(rctrl81) v(xcase81.s1) v(xcase81.s2) v(vdd81)
ac dec 50 1meg 100g
wrdata ac_416.txt v(outp0) v(outn0) v(vid0) v(outp81) v(outn81) v(vid81)
alter Vr0 1.512
alter Vc0 0.486
op
wrdata op_417.txt i(vsupply0) v(xcase0.att_n0) v(xcase0.att_n1) v(xcase0.att_n2) v(xcase0.att_p0) v(xcase0.att_p1) v(xcase0.att_p2) v(cctrl0) v(cm0) v(xcase0.inn) v(xcase0.inp) v(inx0) v(iny0) v(xcase0.nbias) v(outn0) v(outp0) v(xcase0.p_bias) v(xcase0.rc_ct) v(xcase0.rc_gate) v(xcase0.rc_mid) v(rctrl0) v(xcase0.s1) v(xcase0.s2) v(vdd0) i(vsupply81) v(xcase81.att_n0) v(xcase81.att_n1) v(xcase81.att_n2) v(xcase81.att_p0) v(xcase81.att_p1) v(xcase81.att_p2) v(cctrl81) v(cm81) v(xcase81.inn) v(xcase81.inp) v(inx81) v(iny81) v(xcase81.nbias) v(outn81) v(outp81) v(xcase81.p_bias) v(rctrl81) v(xcase81.s1) v(xcase81.s2) v(vdd81)
ac dec 50 1meg 100g
wrdata ac_417.txt v(outp0) v(outn0) v(vid0) v(outp81) v(outn81) v(vid81)
alter Vr0 1.512
alter Vc0 0.513
op
wrdata op_418.txt i(vsupply0) v(xcase0.att_n0) v(xcase0.att_n1) v(xcase0.att_n2) v(xcase0.att_p0) v(xcase0.att_p1) v(xcase0.att_p2) v(cctrl0) v(cm0) v(xcase0.inn) v(xcase0.inp) v(inx0) v(iny0) v(xcase0.nbias) v(outn0) v(outp0) v(xcase0.p_bias) v(xcase0.rc_ct) v(xcase0.rc_gate) v(xcase0.rc_mid) v(rctrl0) v(xcase0.s1) v(xcase0.s2) v(vdd0) i(vsupply81) v(xcase81.att_n0) v(xcase81.att_n1) v(xcase81.att_n2) v(xcase81.att_p0) v(xcase81.att_p1) v(xcase81.att_p2) v(cctrl81) v(cm81) v(xcase81.inn) v(xcase81.inp) v(inx81) v(iny81) v(xcase81.nbias) v(outn81) v(outp81) v(xcase81.p_bias) v(rctrl81) v(xcase81.s1) v(xcase81.s2) v(vdd81)
ac dec 50 1meg 100g
wrdata ac_418.txt v(outp0) v(outn0) v(vid0) v(outp81) v(outn81) v(vid81)
alter Vr0 1.512
alter Vc0 0.54
op
wrdata op_419.txt i(vsupply0) v(xcase0.att_n0) v(xcase0.att_n1) v(xcase0.att_n2) v(xcase0.att_p0) v(xcase0.att_p1) v(xcase0.att_p2) v(cctrl0) v(cm0) v(xcase0.inn) v(xcase0.inp) v(inx0) v(iny0) v(xcase0.nbias) v(outn0) v(outp0) v(xcase0.p_bias) v(xcase0.rc_ct) v(xcase0.rc_gate) v(xcase0.rc_mid) v(rctrl0) v(xcase0.s1) v(xcase0.s2) v(vdd0) i(vsupply81) v(xcase81.att_n0) v(xcase81.att_n1) v(xcase81.att_n2) v(xcase81.att_p0) v(xcase81.att_p1) v(xcase81.att_p2) v(cctrl81) v(cm81) v(xcase81.inn) v(xcase81.inp) v(inx81) v(iny81) v(xcase81.nbias) v(outn81) v(outp81) v(xcase81.p_bias) v(rctrl81) v(xcase81.s1) v(xcase81.s2) v(vdd81)
ac dec 50 1meg 100g
wrdata ac_419.txt v(outp0) v(outn0) v(vid0) v(outp81) v(outn81) v(vid81)
alter Vr0 1.53
alter Vc0 0
op
wrdata op_420.txt i(vsupply0) v(xcase0.att_n0) v(xcase0.att_n1) v(xcase0.att_n2) v(xcase0.att_p0) v(xcase0.att_p1) v(xcase0.att_p2) v(cctrl0) v(cm0) v(xcase0.inn) v(xcase0.inp) v(inx0) v(iny0) v(xcase0.nbias) v(outn0) v(outp0) v(xcase0.p_bias) v(xcase0.rc_ct) v(xcase0.rc_gate) v(xcase0.rc_mid) v(rctrl0) v(xcase0.s1) v(xcase0.s2) v(vdd0) i(vsupply81) v(xcase81.att_n0) v(xcase81.att_n1) v(xcase81.att_n2) v(xcase81.att_p0) v(xcase81.att_p1) v(xcase81.att_p2) v(cctrl81) v(cm81) v(xcase81.inn) v(xcase81.inp) v(inx81) v(iny81) v(xcase81.nbias) v(outn81) v(outp81) v(xcase81.p_bias) v(rctrl81) v(xcase81.s1) v(xcase81.s2) v(vdd81)
ac dec 50 1meg 100g
wrdata ac_420.txt v(outp0) v(outn0) v(vid0) v(outp81) v(outn81) v(vid81)
alter Vr0 1.53
alter Vc0 0.027
op
wrdata op_421.txt i(vsupply0) v(xcase0.att_n0) v(xcase0.att_n1) v(xcase0.att_n2) v(xcase0.att_p0) v(xcase0.att_p1) v(xcase0.att_p2) v(cctrl0) v(cm0) v(xcase0.inn) v(xcase0.inp) v(inx0) v(iny0) v(xcase0.nbias) v(outn0) v(outp0) v(xcase0.p_bias) v(xcase0.rc_ct) v(xcase0.rc_gate) v(xcase0.rc_mid) v(rctrl0) v(xcase0.s1) v(xcase0.s2) v(vdd0) i(vsupply81) v(xcase81.att_n0) v(xcase81.att_n1) v(xcase81.att_n2) v(xcase81.att_p0) v(xcase81.att_p1) v(xcase81.att_p2) v(cctrl81) v(cm81) v(xcase81.inn) v(xcase81.inp) v(inx81) v(iny81) v(xcase81.nbias) v(outn81) v(outp81) v(xcase81.p_bias) v(rctrl81) v(xcase81.s1) v(xcase81.s2) v(vdd81)
ac dec 50 1meg 100g
wrdata ac_421.txt v(outp0) v(outn0) v(vid0) v(outp81) v(outn81) v(vid81)
alter Vr0 1.53
alter Vc0 0.054
op
wrdata op_422.txt i(vsupply0) v(xcase0.att_n0) v(xcase0.att_n1) v(xcase0.att_n2) v(xcase0.att_p0) v(xcase0.att_p1) v(xcase0.att_p2) v(cctrl0) v(cm0) v(xcase0.inn) v(xcase0.inp) v(inx0) v(iny0) v(xcase0.nbias) v(outn0) v(outp0) v(xcase0.p_bias) v(xcase0.rc_ct) v(xcase0.rc_gate) v(xcase0.rc_mid) v(rctrl0) v(xcase0.s1) v(xcase0.s2) v(vdd0) i(vsupply81) v(xcase81.att_n0) v(xcase81.att_n1) v(xcase81.att_n2) v(xcase81.att_p0) v(xcase81.att_p1) v(xcase81.att_p2) v(cctrl81) v(cm81) v(xcase81.inn) v(xcase81.inp) v(inx81) v(iny81) v(xcase81.nbias) v(outn81) v(outp81) v(xcase81.p_bias) v(rctrl81) v(xcase81.s1) v(xcase81.s2) v(vdd81)
ac dec 50 1meg 100g
wrdata ac_422.txt v(outp0) v(outn0) v(vid0) v(outp81) v(outn81) v(vid81)
alter Vr0 1.53
alter Vc0 0.081
op
wrdata op_423.txt i(vsupply0) v(xcase0.att_n0) v(xcase0.att_n1) v(xcase0.att_n2) v(xcase0.att_p0) v(xcase0.att_p1) v(xcase0.att_p2) v(cctrl0) v(cm0) v(xcase0.inn) v(xcase0.inp) v(inx0) v(iny0) v(xcase0.nbias) v(outn0) v(outp0) v(xcase0.p_bias) v(xcase0.rc_ct) v(xcase0.rc_gate) v(xcase0.rc_mid) v(rctrl0) v(xcase0.s1) v(xcase0.s2) v(vdd0) i(vsupply81) v(xcase81.att_n0) v(xcase81.att_n1) v(xcase81.att_n2) v(xcase81.att_p0) v(xcase81.att_p1) v(xcase81.att_p2) v(cctrl81) v(cm81) v(xcase81.inn) v(xcase81.inp) v(inx81) v(iny81) v(xcase81.nbias) v(outn81) v(outp81) v(xcase81.p_bias) v(rctrl81) v(xcase81.s1) v(xcase81.s2) v(vdd81)
ac dec 50 1meg 100g
wrdata ac_423.txt v(outp0) v(outn0) v(vid0) v(outp81) v(outn81) v(vid81)
alter Vr0 1.53
alter Vc0 0.108
op
wrdata op_424.txt i(vsupply0) v(xcase0.att_n0) v(xcase0.att_n1) v(xcase0.att_n2) v(xcase0.att_p0) v(xcase0.att_p1) v(xcase0.att_p2) v(cctrl0) v(cm0) v(xcase0.inn) v(xcase0.inp) v(inx0) v(iny0) v(xcase0.nbias) v(outn0) v(outp0) v(xcase0.p_bias) v(xcase0.rc_ct) v(xcase0.rc_gate) v(xcase0.rc_mid) v(rctrl0) v(xcase0.s1) v(xcase0.s2) v(vdd0) i(vsupply81) v(xcase81.att_n0) v(xcase81.att_n1) v(xcase81.att_n2) v(xcase81.att_p0) v(xcase81.att_p1) v(xcase81.att_p2) v(cctrl81) v(cm81) v(xcase81.inn) v(xcase81.inp) v(inx81) v(iny81) v(xcase81.nbias) v(outn81) v(outp81) v(xcase81.p_bias) v(rctrl81) v(xcase81.s1) v(xcase81.s2) v(vdd81)
ac dec 50 1meg 100g
wrdata ac_424.txt v(outp0) v(outn0) v(vid0) v(outp81) v(outn81) v(vid81)
alter Vr0 1.53
alter Vc0 0.135
op
wrdata op_425.txt i(vsupply0) v(xcase0.att_n0) v(xcase0.att_n1) v(xcase0.att_n2) v(xcase0.att_p0) v(xcase0.att_p1) v(xcase0.att_p2) v(cctrl0) v(cm0) v(xcase0.inn) v(xcase0.inp) v(inx0) v(iny0) v(xcase0.nbias) v(outn0) v(outp0) v(xcase0.p_bias) v(xcase0.rc_ct) v(xcase0.rc_gate) v(xcase0.rc_mid) v(rctrl0) v(xcase0.s1) v(xcase0.s2) v(vdd0) i(vsupply81) v(xcase81.att_n0) v(xcase81.att_n1) v(xcase81.att_n2) v(xcase81.att_p0) v(xcase81.att_p1) v(xcase81.att_p2) v(cctrl81) v(cm81) v(xcase81.inn) v(xcase81.inp) v(inx81) v(iny81) v(xcase81.nbias) v(outn81) v(outp81) v(xcase81.p_bias) v(rctrl81) v(xcase81.s1) v(xcase81.s2) v(vdd81)
ac dec 50 1meg 100g
wrdata ac_425.txt v(outp0) v(outn0) v(vid0) v(outp81) v(outn81) v(vid81)
alter Vr0 1.53
alter Vc0 0.162
op
wrdata op_426.txt i(vsupply0) v(xcase0.att_n0) v(xcase0.att_n1) v(xcase0.att_n2) v(xcase0.att_p0) v(xcase0.att_p1) v(xcase0.att_p2) v(cctrl0) v(cm0) v(xcase0.inn) v(xcase0.inp) v(inx0) v(iny0) v(xcase0.nbias) v(outn0) v(outp0) v(xcase0.p_bias) v(xcase0.rc_ct) v(xcase0.rc_gate) v(xcase0.rc_mid) v(rctrl0) v(xcase0.s1) v(xcase0.s2) v(vdd0) i(vsupply81) v(xcase81.att_n0) v(xcase81.att_n1) v(xcase81.att_n2) v(xcase81.att_p0) v(xcase81.att_p1) v(xcase81.att_p2) v(cctrl81) v(cm81) v(xcase81.inn) v(xcase81.inp) v(inx81) v(iny81) v(xcase81.nbias) v(outn81) v(outp81) v(xcase81.p_bias) v(rctrl81) v(xcase81.s1) v(xcase81.s2) v(vdd81)
ac dec 50 1meg 100g
wrdata ac_426.txt v(outp0) v(outn0) v(vid0) v(outp81) v(outn81) v(vid81)
alter Vr0 1.53
alter Vc0 0.189
op
wrdata op_427.txt i(vsupply0) v(xcase0.att_n0) v(xcase0.att_n1) v(xcase0.att_n2) v(xcase0.att_p0) v(xcase0.att_p1) v(xcase0.att_p2) v(cctrl0) v(cm0) v(xcase0.inn) v(xcase0.inp) v(inx0) v(iny0) v(xcase0.nbias) v(outn0) v(outp0) v(xcase0.p_bias) v(xcase0.rc_ct) v(xcase0.rc_gate) v(xcase0.rc_mid) v(rctrl0) v(xcase0.s1) v(xcase0.s2) v(vdd0) i(vsupply81) v(xcase81.att_n0) v(xcase81.att_n1) v(xcase81.att_n2) v(xcase81.att_p0) v(xcase81.att_p1) v(xcase81.att_p2) v(cctrl81) v(cm81) v(xcase81.inn) v(xcase81.inp) v(inx81) v(iny81) v(xcase81.nbias) v(outn81) v(outp81) v(xcase81.p_bias) v(rctrl81) v(xcase81.s1) v(xcase81.s2) v(vdd81)
ac dec 50 1meg 100g
wrdata ac_427.txt v(outp0) v(outn0) v(vid0) v(outp81) v(outn81) v(vid81)
alter Vr0 1.53
alter Vc0 0.216
op
wrdata op_428.txt i(vsupply0) v(xcase0.att_n0) v(xcase0.att_n1) v(xcase0.att_n2) v(xcase0.att_p0) v(xcase0.att_p1) v(xcase0.att_p2) v(cctrl0) v(cm0) v(xcase0.inn) v(xcase0.inp) v(inx0) v(iny0) v(xcase0.nbias) v(outn0) v(outp0) v(xcase0.p_bias) v(xcase0.rc_ct) v(xcase0.rc_gate) v(xcase0.rc_mid) v(rctrl0) v(xcase0.s1) v(xcase0.s2) v(vdd0) i(vsupply81) v(xcase81.att_n0) v(xcase81.att_n1) v(xcase81.att_n2) v(xcase81.att_p0) v(xcase81.att_p1) v(xcase81.att_p2) v(cctrl81) v(cm81) v(xcase81.inn) v(xcase81.inp) v(inx81) v(iny81) v(xcase81.nbias) v(outn81) v(outp81) v(xcase81.p_bias) v(rctrl81) v(xcase81.s1) v(xcase81.s2) v(vdd81)
ac dec 50 1meg 100g
wrdata ac_428.txt v(outp0) v(outn0) v(vid0) v(outp81) v(outn81) v(vid81)
alter Vr0 1.53
alter Vc0 0.243
op
wrdata op_429.txt i(vsupply0) v(xcase0.att_n0) v(xcase0.att_n1) v(xcase0.att_n2) v(xcase0.att_p0) v(xcase0.att_p1) v(xcase0.att_p2) v(cctrl0) v(cm0) v(xcase0.inn) v(xcase0.inp) v(inx0) v(iny0) v(xcase0.nbias) v(outn0) v(outp0) v(xcase0.p_bias) v(xcase0.rc_ct) v(xcase0.rc_gate) v(xcase0.rc_mid) v(rctrl0) v(xcase0.s1) v(xcase0.s2) v(vdd0) i(vsupply81) v(xcase81.att_n0) v(xcase81.att_n1) v(xcase81.att_n2) v(xcase81.att_p0) v(xcase81.att_p1) v(xcase81.att_p2) v(cctrl81) v(cm81) v(xcase81.inn) v(xcase81.inp) v(inx81) v(iny81) v(xcase81.nbias) v(outn81) v(outp81) v(xcase81.p_bias) v(rctrl81) v(xcase81.s1) v(xcase81.s2) v(vdd81)
ac dec 50 1meg 100g
wrdata ac_429.txt v(outp0) v(outn0) v(vid0) v(outp81) v(outn81) v(vid81)
alter Vr0 1.53
alter Vc0 0.27
op
wrdata op_430.txt i(vsupply0) v(xcase0.att_n0) v(xcase0.att_n1) v(xcase0.att_n2) v(xcase0.att_p0) v(xcase0.att_p1) v(xcase0.att_p2) v(cctrl0) v(cm0) v(xcase0.inn) v(xcase0.inp) v(inx0) v(iny0) v(xcase0.nbias) v(outn0) v(outp0) v(xcase0.p_bias) v(xcase0.rc_ct) v(xcase0.rc_gate) v(xcase0.rc_mid) v(rctrl0) v(xcase0.s1) v(xcase0.s2) v(vdd0) i(vsupply81) v(xcase81.att_n0) v(xcase81.att_n1) v(xcase81.att_n2) v(xcase81.att_p0) v(xcase81.att_p1) v(xcase81.att_p2) v(cctrl81) v(cm81) v(xcase81.inn) v(xcase81.inp) v(inx81) v(iny81) v(xcase81.nbias) v(outn81) v(outp81) v(xcase81.p_bias) v(rctrl81) v(xcase81.s1) v(xcase81.s2) v(vdd81)
ac dec 50 1meg 100g
wrdata ac_430.txt v(outp0) v(outn0) v(vid0) v(outp81) v(outn81) v(vid81)
alter Vr0 1.53
alter Vc0 0.297
op
wrdata op_431.txt i(vsupply0) v(xcase0.att_n0) v(xcase0.att_n1) v(xcase0.att_n2) v(xcase0.att_p0) v(xcase0.att_p1) v(xcase0.att_p2) v(cctrl0) v(cm0) v(xcase0.inn) v(xcase0.inp) v(inx0) v(iny0) v(xcase0.nbias) v(outn0) v(outp0) v(xcase0.p_bias) v(xcase0.rc_ct) v(xcase0.rc_gate) v(xcase0.rc_mid) v(rctrl0) v(xcase0.s1) v(xcase0.s2) v(vdd0) i(vsupply81) v(xcase81.att_n0) v(xcase81.att_n1) v(xcase81.att_n2) v(xcase81.att_p0) v(xcase81.att_p1) v(xcase81.att_p2) v(cctrl81) v(cm81) v(xcase81.inn) v(xcase81.inp) v(inx81) v(iny81) v(xcase81.nbias) v(outn81) v(outp81) v(xcase81.p_bias) v(rctrl81) v(xcase81.s1) v(xcase81.s2) v(vdd81)
ac dec 50 1meg 100g
wrdata ac_431.txt v(outp0) v(outn0) v(vid0) v(outp81) v(outn81) v(vid81)
alter Vr0 1.53
alter Vc0 0.324
op
wrdata op_432.txt i(vsupply0) v(xcase0.att_n0) v(xcase0.att_n1) v(xcase0.att_n2) v(xcase0.att_p0) v(xcase0.att_p1) v(xcase0.att_p2) v(cctrl0) v(cm0) v(xcase0.inn) v(xcase0.inp) v(inx0) v(iny0) v(xcase0.nbias) v(outn0) v(outp0) v(xcase0.p_bias) v(xcase0.rc_ct) v(xcase0.rc_gate) v(xcase0.rc_mid) v(rctrl0) v(xcase0.s1) v(xcase0.s2) v(vdd0) i(vsupply81) v(xcase81.att_n0) v(xcase81.att_n1) v(xcase81.att_n2) v(xcase81.att_p0) v(xcase81.att_p1) v(xcase81.att_p2) v(cctrl81) v(cm81) v(xcase81.inn) v(xcase81.inp) v(inx81) v(iny81) v(xcase81.nbias) v(outn81) v(outp81) v(xcase81.p_bias) v(rctrl81) v(xcase81.s1) v(xcase81.s2) v(vdd81)
ac dec 50 1meg 100g
wrdata ac_432.txt v(outp0) v(outn0) v(vid0) v(outp81) v(outn81) v(vid81)
alter Vr0 1.53
alter Vc0 0.351
op
wrdata op_433.txt i(vsupply0) v(xcase0.att_n0) v(xcase0.att_n1) v(xcase0.att_n2) v(xcase0.att_p0) v(xcase0.att_p1) v(xcase0.att_p2) v(cctrl0) v(cm0) v(xcase0.inn) v(xcase0.inp) v(inx0) v(iny0) v(xcase0.nbias) v(outn0) v(outp0) v(xcase0.p_bias) v(xcase0.rc_ct) v(xcase0.rc_gate) v(xcase0.rc_mid) v(rctrl0) v(xcase0.s1) v(xcase0.s2) v(vdd0) i(vsupply81) v(xcase81.att_n0) v(xcase81.att_n1) v(xcase81.att_n2) v(xcase81.att_p0) v(xcase81.att_p1) v(xcase81.att_p2) v(cctrl81) v(cm81) v(xcase81.inn) v(xcase81.inp) v(inx81) v(iny81) v(xcase81.nbias) v(outn81) v(outp81) v(xcase81.p_bias) v(rctrl81) v(xcase81.s1) v(xcase81.s2) v(vdd81)
ac dec 50 1meg 100g
wrdata ac_433.txt v(outp0) v(outn0) v(vid0) v(outp81) v(outn81) v(vid81)
alter Vr0 1.53
alter Vc0 0.378
op
wrdata op_434.txt i(vsupply0) v(xcase0.att_n0) v(xcase0.att_n1) v(xcase0.att_n2) v(xcase0.att_p0) v(xcase0.att_p1) v(xcase0.att_p2) v(cctrl0) v(cm0) v(xcase0.inn) v(xcase0.inp) v(inx0) v(iny0) v(xcase0.nbias) v(outn0) v(outp0) v(xcase0.p_bias) v(xcase0.rc_ct) v(xcase0.rc_gate) v(xcase0.rc_mid) v(rctrl0) v(xcase0.s1) v(xcase0.s2) v(vdd0) i(vsupply81) v(xcase81.att_n0) v(xcase81.att_n1) v(xcase81.att_n2) v(xcase81.att_p0) v(xcase81.att_p1) v(xcase81.att_p2) v(cctrl81) v(cm81) v(xcase81.inn) v(xcase81.inp) v(inx81) v(iny81) v(xcase81.nbias) v(outn81) v(outp81) v(xcase81.p_bias) v(rctrl81) v(xcase81.s1) v(xcase81.s2) v(vdd81)
ac dec 50 1meg 100g
wrdata ac_434.txt v(outp0) v(outn0) v(vid0) v(outp81) v(outn81) v(vid81)
alter Vr0 1.53
alter Vc0 0.405
op
wrdata op_435.txt i(vsupply0) v(xcase0.att_n0) v(xcase0.att_n1) v(xcase0.att_n2) v(xcase0.att_p0) v(xcase0.att_p1) v(xcase0.att_p2) v(cctrl0) v(cm0) v(xcase0.inn) v(xcase0.inp) v(inx0) v(iny0) v(xcase0.nbias) v(outn0) v(outp0) v(xcase0.p_bias) v(xcase0.rc_ct) v(xcase0.rc_gate) v(xcase0.rc_mid) v(rctrl0) v(xcase0.s1) v(xcase0.s2) v(vdd0) i(vsupply81) v(xcase81.att_n0) v(xcase81.att_n1) v(xcase81.att_n2) v(xcase81.att_p0) v(xcase81.att_p1) v(xcase81.att_p2) v(cctrl81) v(cm81) v(xcase81.inn) v(xcase81.inp) v(inx81) v(iny81) v(xcase81.nbias) v(outn81) v(outp81) v(xcase81.p_bias) v(rctrl81) v(xcase81.s1) v(xcase81.s2) v(vdd81)
ac dec 50 1meg 100g
wrdata ac_435.txt v(outp0) v(outn0) v(vid0) v(outp81) v(outn81) v(vid81)
alter Vr0 1.53
alter Vc0 0.432
op
wrdata op_436.txt i(vsupply0) v(xcase0.att_n0) v(xcase0.att_n1) v(xcase0.att_n2) v(xcase0.att_p0) v(xcase0.att_p1) v(xcase0.att_p2) v(cctrl0) v(cm0) v(xcase0.inn) v(xcase0.inp) v(inx0) v(iny0) v(xcase0.nbias) v(outn0) v(outp0) v(xcase0.p_bias) v(xcase0.rc_ct) v(xcase0.rc_gate) v(xcase0.rc_mid) v(rctrl0) v(xcase0.s1) v(xcase0.s2) v(vdd0) i(vsupply81) v(xcase81.att_n0) v(xcase81.att_n1) v(xcase81.att_n2) v(xcase81.att_p0) v(xcase81.att_p1) v(xcase81.att_p2) v(cctrl81) v(cm81) v(xcase81.inn) v(xcase81.inp) v(inx81) v(iny81) v(xcase81.nbias) v(outn81) v(outp81) v(xcase81.p_bias) v(rctrl81) v(xcase81.s1) v(xcase81.s2) v(vdd81)
ac dec 50 1meg 100g
wrdata ac_436.txt v(outp0) v(outn0) v(vid0) v(outp81) v(outn81) v(vid81)
alter Vr0 1.53
alter Vc0 0.459
op
wrdata op_437.txt i(vsupply0) v(xcase0.att_n0) v(xcase0.att_n1) v(xcase0.att_n2) v(xcase0.att_p0) v(xcase0.att_p1) v(xcase0.att_p2) v(cctrl0) v(cm0) v(xcase0.inn) v(xcase0.inp) v(inx0) v(iny0) v(xcase0.nbias) v(outn0) v(outp0) v(xcase0.p_bias) v(xcase0.rc_ct) v(xcase0.rc_gate) v(xcase0.rc_mid) v(rctrl0) v(xcase0.s1) v(xcase0.s2) v(vdd0) i(vsupply81) v(xcase81.att_n0) v(xcase81.att_n1) v(xcase81.att_n2) v(xcase81.att_p0) v(xcase81.att_p1) v(xcase81.att_p2) v(cctrl81) v(cm81) v(xcase81.inn) v(xcase81.inp) v(inx81) v(iny81) v(xcase81.nbias) v(outn81) v(outp81) v(xcase81.p_bias) v(rctrl81) v(xcase81.s1) v(xcase81.s2) v(vdd81)
ac dec 50 1meg 100g
wrdata ac_437.txt v(outp0) v(outn0) v(vid0) v(outp81) v(outn81) v(vid81)
alter Vr0 1.53
alter Vc0 0.486
op
wrdata op_438.txt i(vsupply0) v(xcase0.att_n0) v(xcase0.att_n1) v(xcase0.att_n2) v(xcase0.att_p0) v(xcase0.att_p1) v(xcase0.att_p2) v(cctrl0) v(cm0) v(xcase0.inn) v(xcase0.inp) v(inx0) v(iny0) v(xcase0.nbias) v(outn0) v(outp0) v(xcase0.p_bias) v(xcase0.rc_ct) v(xcase0.rc_gate) v(xcase0.rc_mid) v(rctrl0) v(xcase0.s1) v(xcase0.s2) v(vdd0) i(vsupply81) v(xcase81.att_n0) v(xcase81.att_n1) v(xcase81.att_n2) v(xcase81.att_p0) v(xcase81.att_p1) v(xcase81.att_p2) v(cctrl81) v(cm81) v(xcase81.inn) v(xcase81.inp) v(inx81) v(iny81) v(xcase81.nbias) v(outn81) v(outp81) v(xcase81.p_bias) v(rctrl81) v(xcase81.s1) v(xcase81.s2) v(vdd81)
ac dec 50 1meg 100g
wrdata ac_438.txt v(outp0) v(outn0) v(vid0) v(outp81) v(outn81) v(vid81)
alter Vr0 1.53
alter Vc0 0.513
op
wrdata op_439.txt i(vsupply0) v(xcase0.att_n0) v(xcase0.att_n1) v(xcase0.att_n2) v(xcase0.att_p0) v(xcase0.att_p1) v(xcase0.att_p2) v(cctrl0) v(cm0) v(xcase0.inn) v(xcase0.inp) v(inx0) v(iny0) v(xcase0.nbias) v(outn0) v(outp0) v(xcase0.p_bias) v(xcase0.rc_ct) v(xcase0.rc_gate) v(xcase0.rc_mid) v(rctrl0) v(xcase0.s1) v(xcase0.s2) v(vdd0) i(vsupply81) v(xcase81.att_n0) v(xcase81.att_n1) v(xcase81.att_n2) v(xcase81.att_p0) v(xcase81.att_p1) v(xcase81.att_p2) v(cctrl81) v(cm81) v(xcase81.inn) v(xcase81.inp) v(inx81) v(iny81) v(xcase81.nbias) v(outn81) v(outp81) v(xcase81.p_bias) v(rctrl81) v(xcase81.s1) v(xcase81.s2) v(vdd81)
ac dec 50 1meg 100g
wrdata ac_439.txt v(outp0) v(outn0) v(vid0) v(outp81) v(outn81) v(vid81)
alter Vr0 1.53
alter Vc0 0.54
op
wrdata op_440.txt i(vsupply0) v(xcase0.att_n0) v(xcase0.att_n1) v(xcase0.att_n2) v(xcase0.att_p0) v(xcase0.att_p1) v(xcase0.att_p2) v(cctrl0) v(cm0) v(xcase0.inn) v(xcase0.inp) v(inx0) v(iny0) v(xcase0.nbias) v(outn0) v(outp0) v(xcase0.p_bias) v(xcase0.rc_ct) v(xcase0.rc_gate) v(xcase0.rc_mid) v(rctrl0) v(xcase0.s1) v(xcase0.s2) v(vdd0) i(vsupply81) v(xcase81.att_n0) v(xcase81.att_n1) v(xcase81.att_n2) v(xcase81.att_p0) v(xcase81.att_p1) v(xcase81.att_p2) v(cctrl81) v(cm81) v(xcase81.inn) v(xcase81.inp) v(inx81) v(iny81) v(xcase81.nbias) v(outn81) v(outp81) v(xcase81.p_bias) v(rctrl81) v(xcase81.s1) v(xcase81.s2) v(vdd81)
ac dec 50 1meg 100g
wrdata ac_440.txt v(outp0) v(outn0) v(vid0) v(outp81) v(outn81) v(vid81)
quit
.endc
.end
