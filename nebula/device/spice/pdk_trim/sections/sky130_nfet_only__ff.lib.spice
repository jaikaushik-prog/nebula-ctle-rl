* GENERATED by nebula/device/pdk_trim.py -- DO NOT EDIT.
* Regenerate with: python -m nebula.device.pdk_trim --write
*
* Section `ff` of sky130_nfet_only.lib.spice, ALONE in its own file.
*
* WHY THIS FILE EXISTS, and it is the largest single throughput finding in
* this project: **ngspice expands EVERY `.lib` section in a file, not only the
* one you asked for.** Measured on the same trivial netlist, same machine:
*
*     extended library, this one section extracted   0.093 s
*     extended library, real 25-section file         1.386 s   <- 15x
*     nfet-only library, real 5-section file         0.297 s
*
* The cost scales with the SECTION COUNT, not with what the netlist uses. The
* extended library's 25 sections are the 5x5 (MOS x passive) corner cross
* product G58 added, so the file got 5x bigger the day the passive corner axis
* arrived and the per-evaluation cost went with it. Splitting is the fix; the
* section a run asks for is the only one it now pays for.
*
* Bit-identity to the monolithic library is asserted at rel=0, abs=0 by
* nebula/tests/test_pdk_trim.py.

.lib ff
.option scale=1.0u
.param mc_mm_switch=0
.param mc_pr_switch=0
.include "C:/Users/DELL/sky130A/libs.ref/sky130_fd_pr/spice/sky130_fd_pr__nfet_01v8__ff.pm3.spice"
.include "C:/Users/DELL/sky130A/libs.ref/sky130_fd_pr/spice/sky130_fd_pr__nfet_01v8__mismatch.corner.spice"
.endl ff
