* GENERATED by nebula/device/pdk_trim.py -- DO NOT EDIT.
* Regenerate with: python -m nebula.device.pdk_trim --write
*
* Section `fs_hh` of sky130_ctle_pfet.lib.spice, ALONE in its own file.
*
* WHY THIS FILE EXISTS, and it is the largest single throughput finding in
* this project: **ngspice expands EVERY `.lib` section in a file, not only the
* one you asked for.** Measured on the same trivial netlist, same machine:
*
*     extended library, this one section extracted   0.093 s
*     extended library, real 25-section file         1.386 s   <- 15x
*     nfet-only library, real 5-section file         0.297 s
*
* The cost scales with the SECTION COUNT, not with what the netlist uses. The
* extended library's 25 sections are the 5x5 (MOS x passive) corner cross
* product G58 added, so the file got 5x bigger the day the passive corner axis
* arrived and the per-evaluation cost went with it. Splitting is the fix; the
* section a run asks for is the only one it now pays for.
*
* Bit-identity to the monolithic library is asserted at rel=0, abs=0 by
* nebula/tests/test_pdk_trim.py.

.lib fs_hh
.option scale=1.0u
.param mc_mm_switch=0
.param mc_pr_switch=0
.include "../pfet_lod.trim.spice"
.include "../pfet_invariant.trim.spice"
* --- MOSFET ---
.include "C:/Users/DELL/sky130A/libs.ref/sky130_fd_pr/spice/sky130_fd_pr__nfet_01v8__fs.pm3.spice"
.include "C:/Users/DELL/sky130A/libs.ref/sky130_fd_pr/spice/sky130_fd_pr__pfet_01v8__fs.pm3.spice"
.include "C:/Users/DELL/sky130A/libs.ref/sky130_fd_pr/spice/sky130_fd_pr__nfet_01v8__mismatch.corner.spice"
.include "C:/Users/DELL/sky130A/libs.ref/sky130_fd_pr/spice/sky130_fd_pr__pfet_01v8__mismatch.corner.spice"
* --- Resistor / capacitor process parameters ---
.include "../res_high__cap_high.spice"
.include "C:/Users/DELL/sky130A/libs.tech/ngspice/r+c/res_high__cap_high__lin.spice"
* --- Passive devices ---
.include "C:/Users/DELL/sky130A/libs.tech/ngspice/parasitics/sky130_fd_pr__model__parasitic__res_po.model.spice"
.include "C:/Users/DELL/sky130A/libs.ref/sky130_fd_pr/spice/sky130_fd_pr__res_high_po.model.spice"
.include "C:/Users/DELL/sky130A/libs.ref/sky130_fd_pr/spice/sky130_fd_pr__res_xhigh_po.model.spice"
.include "C:/Users/DELL/sky130A/libs.ref/sky130_fd_pr/spice/sky130_fd_pr__res_xhigh_po__base.model.spice"
.include "C:/Users/DELL/sky130A/libs.ref/sky130_fd_pr/spice/sky130_fd_pr__res_high_po_0p35.model.spice"
.include "C:/Users/DELL/sky130A/libs.ref/sky130_fd_pr/spice/sky130_fd_pr__res_high_po_0p69.model.spice"
.include "C:/Users/DELL/sky130A/libs.ref/sky130_fd_pr/spice/sky130_fd_pr__res_high_po_1p41.model.spice"
.include "C:/Users/DELL/sky130A/libs.ref/sky130_fd_pr/spice/sky130_fd_pr__res_high_po_2p85.model.spice"
.include "C:/Users/DELL/sky130A/libs.ref/sky130_fd_pr/spice/sky130_fd_pr__res_high_po_5p73.model.spice"
.include "C:/Users/DELL/sky130A/libs.ref/sky130_fd_pr/spice/sky130_fd_pr__res_xhigh_po_0p35.model.spice"
.include "C:/Users/DELL/sky130A/libs.ref/sky130_fd_pr/spice/sky130_fd_pr__res_xhigh_po_0p69.model.spice"
.include "C:/Users/DELL/sky130A/libs.ref/sky130_fd_pr/spice/sky130_fd_pr__res_xhigh_po_1p41.model.spice"
.include "C:/Users/DELL/sky130A/libs.ref/sky130_fd_pr/spice/sky130_fd_pr__res_xhigh_po_2p85.model.spice"
.include "C:/Users/DELL/sky130A/libs.ref/sky130_fd_pr/spice/sky130_fd_pr__res_xhigh_po_5p73.model.spice"
.include "C:/Users/DELL/sky130A/libs.tech/ngspice/capacitors/sky130_fd_pr__model__cap_mim.model.spice"
.endl fs_hh
