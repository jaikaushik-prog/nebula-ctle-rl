* GENERATED by nebula/device/pdk_trim.py -- DO NOT EDIT.
* Regenerate with: python -m nebula.device.pdk_trim --write
*
* Source: C:/Users/DELL/sky130A/libs.tech/ngspice/parameters/lod.spice
* Kept 8 of 70 .param definition lines (8 of 70 names):
* exactly those reachable from the opt-in PFET model cards,
* closed over right-hand sides. The rest describe vpp fringe caps, flash
* cells, ESD diodes and unrelated devices -- parsed and thrown away.
*
* Order is the PDK's own, so a parameter that depends on an earlier one still
* resolves. Dependency derivation and real-ngspice PMOS instantiation are asserted by
* nebula/tests/test_pfet_attenuator.py.

.param sky130_fd_pr__pfet_01v8__lkvth0_diff = .0e-6
.param sky130_fd_pr__pfet_01v8__wlod_diff = .0e-6
.param sky130_fd_pr__pfet_01v8__lku0_diff = 0.0
.param sky130_fd_pr__pfet_01v8__kvsat_diff = 0.5
.param sky130_fd_pr__pfet_01v8__kvth0_diff = 3.29e-8
.param sky130_fd_pr__pfet_01v8__wkvth0_diff = .20e-6
.param sky130_fd_pr__pfet_01v8__ku0_diff = 4.5e-8
.param sky130_fd_pr__pfet_01v8__wku0_diff = .25e-6
