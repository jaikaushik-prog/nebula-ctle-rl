* GENERATED by nebula/device/pdk_trim.py -- DO NOT EDIT.
* Regenerate with: python -m nebula.device.pdk_trim --write
*
* Source: C:/Users/DELL/sky130A/libs.tech/ngspice/parameters/fast_70p.spice
* Kept 43 of 3021 .param definition lines (86 of 8909 names):
* exactly those reachable from the model cards sky130_ctle.lib.spice includes,
* closed over right-hand sides. The rest describe vpp fringe caps, flash
* cells, ESD diodes, 20 V devices and the pfet set -- parsed and thrown away.
*
* Order is the PDK's own, so a parameter that depends on an earlier one still
* resolves. Equivalence to the untrimmed deck is asserted at rel=0, abs=0 by
* nebula/tests/test_pdk_trim.py, which also re-derives this file byte for byte.

.param cp1f = 8.67e-05  cp1fsw = 7.73e-11
.param cl1f = 3.12e-05  cl1fsw = 7.23e-11
.param cl1d = 4.77e-05  cl1dsw = 7.16e-11
.param cl1p1 = 7.09e-05  cl1p1sw = 7.10e-11
.param cm1f = 2.17e-05  cm1fsw = 9.36e-11
.param cm1d = 2.86e-05  cm1dsw = 9.34e-11
.param cm1p1 = 3.55e-05  cm1p1sw = 9.31e-11
.param cm1l1 = 8.73e-05  cm1l1sw = 9.20e-11
.param cm2f = 1.49e-05  cm2fsw = 9.39e-11
.param cm2d = 1.79e-05  cm2dsw = 9.38e-11
.param cm2p1 = 2.04e-05  cm2p1sw = 9.37e-11
.param cm2l1 = 3.10e-05  cm2l1sw = 9.35e-11
.param cm2m1 = 9.04e-05  cm2m1sw = 9.20e-11
.param cm3f = 1.08e-05  cm3fsw = 9.74e-11
.param cm3d = 1.23e-05  cm3dsw = 9.72e-11
.param cm3p1 = 1.35e-05  cm3p1sw = 9.72e-11
.param cm3l1 = 1.74e-05  cm3l1sw = 9.68e-11
.param cm3m1 = 2.75e-05  cm3m1sw = 9.60e-11
.param cm3m2 = 6.49e-05  cm3m2sw = 9.45e-11
.param cm4f = 7.66e-06  cm4fsw = 9.80e-11
.param cm4d = 8.37e-06  cm4dsw = 9.80e-11
.param cm4p1 = 8.88e-06  cm4p1sw = 9.78e-11
.param cm4l1 = 1.04e-05  cm4l1sw = 9.77e-11
.param cm4m1 = 1.34e-05  cm4m1sw = 9.74e-11
.param cm4m2 = 1.86e-05  cm4m2sw = 9.69e-11
.param cm4m3 = 6.43e-05  cm4m3sw = 9.50e-11
.param cm5f = 5.81e-06  cm5fsw = 7.20e-11
.param cm5d = 6.21e-06  cm5dsw = 7.19e-11
.param cm5p1 = 6.49e-06  cm5p1sw = 7.18e-11
.param cm5l1 = 7.27e-06  cm5l1sw = 7.15e-11
.param cm5m1 = 8.59e-06  cm5m1sw = 7.12e-11
.param cm5m2 = 1.05e-05  cm5m2sw = 7.09e-11
.param cm5m3 = 1.75e-05  cm5m3sw = 7.09e-11
.param cm5m4 = 5.30e-05  cm5m4sw = 7.88e-11
.param crdlf = 2.26e-06  crdlfsw = 4.99e-11
.param crdld = 2.32e-06  crdldsw = 4.98e-11
.param crdlp1 = 2.36e-06  crdlp1sw = 4.98e-11
.param crdll1 = 2.45e-06  crdll1sw = 4.97e-11
.param crdlm1 = 2.58e-06  crdlm1sw = 4.95e-11
.param crdlm2 = 2.73e-06  crdlm2sw = 4.94e-11
.param crdlm3 = 3.06e-06  crdlm3sw = 4.92e-11
.param crdlm4 = 3.47e-06  crdlm4sw = 4.91e-11
.param crdlm5 = 4.58e-06  crdlm5sw = 4.93e-11
